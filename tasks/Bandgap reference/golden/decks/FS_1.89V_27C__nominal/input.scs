// Design: DAC_20261107_BGR/bgr_nominal_tb
simulator lang=spectre
global 0
parameters VS=1.89
include "<PDK_ROOT>/sky130_cds/spectre/libs.tech/spectre/sky130.lib.spice" section=fs

// DAC_20261107_BGR/bgr_fig3_paper/schematic
subckt bgr_fig3_paper GND VDD VREF
    M11 (N2 VINP TAIL VDD) sky130_fd_pr__pfet_01v8 w=17.2163830408 l=1.88126024368 nf=1 mult=1
    M10 (N1 VINN TAIL VDD) sky130_fd_pr__pfet_01v8 w=18.5728001195 l=1.88126024368 nf=1 mult=1
    M8 (BIAS PB VDD VDD) sky130_fd_pr__pfet_01v8 w=28 l=0.15 nf=1 mult=1
    M7 (TAIL PB VDD VDD) sky130_fd_pr__pfet_01v8 w=13.0132015624 l=0.15 nf=1 mult=1
    M6 (PB PB VDD VDD) sky130_fd_pr__pfet_01v8 w=13.0132015624 l=0.15 nf=1 mult=1
    M3 (VREF BIAS VDD VDD) sky130_fd_pr__pfet_01v8 w=8.11936491609 l=2.03241167666 nf=1 mult=1
    M2 (VINP BIAS VDD VDD) sky130_fd_pr__pfet_01v8 w=8.11936491609 l=2.03241167666 nf=1 mult=1
    M1 (VINN BIAS VDD VDD) sky130_fd_pr__pfet_01v8 w=8.11936491609 l=2.03241167666 nf=1 mult=1
    M13 (N2 N1 GND GND) sky130_fd_pr__nfet_01v8 w=1.67 l=0.189087528433 nf=1 mult=1
    M12 (N1 N1 GND GND) sky130_fd_pr__nfet_01v8 w=1.70316663639 l=0.189087528433 nf=1 mult=1
    M9 (BIAS N2 GND GND) sky130_fd_pr__nfet_01v8 w=80 l=0.3 nf=1 mult=1
    M5_10 (PTAT PTAT GND GND) sky130_fd_pr__nfet_01v8 w=26.3491591964 l=0.501047533903 nf=1 mult=1
    M5_9 (PTAT PTAT GND GND) sky130_fd_pr__nfet_01v8 w=26.3491591964 l=0.501047533903 nf=1 mult=1
    M5_8 (PTAT PTAT GND GND) sky130_fd_pr__nfet_01v8 w=26.3491591964 l=0.501047533903 nf=1 mult=1
    M5_7 (PTAT PTAT GND GND) sky130_fd_pr__nfet_01v8 w=26.3491591964 l=0.501047533903 nf=1 mult=1
    M5_6 (PTAT PTAT GND GND) sky130_fd_pr__nfet_01v8 w=26.3491591964 l=0.501047533903 nf=1 mult=1
    M5_5 (PTAT PTAT GND GND) sky130_fd_pr__nfet_01v8 w=26.3491591964 l=0.501047533903 nf=1 mult=1
    M5_4 (PTAT PTAT GND GND) sky130_fd_pr__nfet_01v8 w=26.3491591964 l=0.501047533903 nf=1 mult=1
    M5_3 (PTAT PTAT GND GND) sky130_fd_pr__nfet_01v8 w=26.3491591964 l=0.501047533903 nf=1 mult=1
    M5_2 (PTAT PTAT GND GND) sky130_fd_pr__nfet_01v8 w=26.3491591964 l=0.501047533903 nf=1 mult=1
    M5_1 (PTAT PTAT GND GND) sky130_fd_pr__nfet_01v8 w=26.3491591964 l=0.501047533903 nf=1 mult=1
    M4 (VINN VINN GND GND) sky130_fd_pr__nfet_01v8 w=18.4523768328 l=0.501047533903 nf=1 mult=1
    R4 (PB GND) resistor r=226657.115086
    R3 (VREF GND) resistor r=118523.473012
    R2 (VINP GND) resistor r=83316.9685779
    R1 (VINP PTAT) resistor r=52001.185432
    CC (N2 BIAS) capacitor c=1e-11
ends bgr_fig3_paper

// DAC_20261107_BGR/bgr_nominal_tb/schematic
DUT (0 VDD VREF) bgr_fig3_paper
VDD_SRC (VDD 0) vsource dc=VS mag=1 type=dc
nodeset VREF=1.2 DUT.BIAS=0.66 DUT.VINP=0.55 DUT.VINN=0.55
simulatorOptions options reltol=1e-05 vabstol=1e-09 iabstol=1e-13 temp=27
tran tran stop=30u maxstep=30n
ac ac start=1 stop=1G dec=50
dcOp dc
saveOptions options currents=all subcktprobelvl=5
