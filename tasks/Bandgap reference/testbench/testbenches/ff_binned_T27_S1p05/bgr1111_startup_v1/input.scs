// analogiq 0.1.0 testbench - generated, do not edit
// task sky130_bandgap_101126_task_001  topology bgr1111_nmos_bandgap
// recipe bgr1111_startup_v1 v1  condition ff_binned_T27_S1p05 (models ff_binned, 27 C, supply 1.89 V)
// request sky130_bandgap_101126_task_001__plan  candidate 810467665e3cbc94
// execution profile search_full
simulator lang=spectre
global 0
include "<PDK_ROOT>/sky130_cds/spectre/libs.tech/spectre/sky130.lib.spice" section=ff
include "dut.scs"

parameters vsup=1.8900000000000001 vneg=0.0
// Supplies (charged to the DUT power metrics).
VSUP (vdd 0) vsource type=pwl wave=[0 0 1e-06 0 2e-06 1.8900000000000001 0.001 1.8900000000000001]
VNEG (vss 0) vsource dc=vneg

// no nodeset: the circuit must start up from 0 V by itself (replay startup deck)

XDUT (vss vdd out) bgr_fig3_paper CC=1e-12 L_M4=1e-06 L_M8=1e-06 L_M9=1e-06 L_NLD=1e-06 L_PBIAS=1e-06 L_PIN=1e-06 L_PMIR=1e-06 L_PTAT=1e-06 M_M10=1.0 M_M11=1.0 M_M12=1.0 M_M13=1.0 M_M4=1.0 M_M8=1.0 M_M9=1.0 M_PBIAS=1.0 M_PMIR=1.0 M_PTAT=1.0 NF_M10=1.0 NF_M11=1.0 NF_M12=1.0 NF_M13=1.0 NF_M4=1.0 NF_M8=1.0 NF_M9=1.0 NF_PBIAS=1.0 NF_PMIR=1.0 NF_PTAT=1.0 R1=10000.0 R2=10000.0 R3=10000.0 R4=10000.0 W_M10=1e-06 W_M11=1e-06 W_M12=1e-06 W_M13=1e-06 W_M4=1e-06 W_M8=1e-06 W_M9=1e-06 W_PBIAS=1e-06 W_PMIR=1e-06 W_PTAT=1e-06

opts options temp=27.0 tnom=27 reltol=0.0001 save=selected
save VNEG:p VSUP:p out vdd vss

bgropts options reltol=1e-05 vabstol=1e-09 iabstol=1e-13 gmin=1e-12 pivrel=0.001 rforce=1 soft_bin=allmodels
tsu tran stop=0.001 maxstep=1e-07 errpreset=conservative
