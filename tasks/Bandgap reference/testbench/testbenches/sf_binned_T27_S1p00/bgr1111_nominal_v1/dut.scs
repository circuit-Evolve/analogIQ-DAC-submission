// Generated by analogiq from dut_sizing.scs (sha256 a0eca7b12eaa7538).
// Connectivity and device models are unchanged except for the listed transformations:
//   - M11: mult bound to M_M11; Spectre multiplicity m follows it
//   - M11: junction geometry ad/as/pd/ps rewritten in terms of the bound width (area = Lj*W, perimeter = 2*W + c; Lj and c from the netlist)
//   - M10: mult bound to M_M10; Spectre multiplicity m follows it
//   - M10: junction geometry ad/as/pd/ps rewritten in terms of the bound width (area = Lj*W, perimeter = 2*W + c; Lj and c from the netlist)
//   - M8: mult bound to M_M8; Spectre multiplicity m follows it
//   - M8: junction geometry ad/as/pd/ps rewritten in terms of the bound width (area = Lj*W, perimeter = 2*W + c; Lj and c from the netlist)
//   - M7: mult bound to M_PBIAS; Spectre multiplicity m follows it
//   - M7: junction geometry ad/as/pd/ps rewritten in terms of the bound width (area = Lj*W, perimeter = 2*W + c; Lj and c from the netlist)
//   - M6: mult bound to M_PBIAS; Spectre multiplicity m follows it
//   - M6: junction geometry ad/as/pd/ps rewritten in terms of the bound width (area = Lj*W, perimeter = 2*W + c; Lj and c from the netlist)
//   - M3: mult bound to M_PMIR; Spectre multiplicity m follows it
//   - M3: junction geometry ad/as/pd/ps rewritten in terms of the bound width (area = Lj*W, perimeter = 2*W + c; Lj and c from the netlist)
//   - M2: mult bound to M_PMIR; Spectre multiplicity m follows it
//   - M2: junction geometry ad/as/pd/ps rewritten in terms of the bound width (area = Lj*W, perimeter = 2*W + c; Lj and c from the netlist)
//   - M1: mult bound to M_PMIR; Spectre multiplicity m follows it
//   - M1: junction geometry ad/as/pd/ps rewritten in terms of the bound width (area = Lj*W, perimeter = 2*W + c; Lj and c from the netlist)
//   - M13: mult bound to M_M13; Spectre multiplicity m follows it
//   - M13: junction geometry ad/as/pd/ps rewritten in terms of the bound width (area = Lj*W, perimeter = 2*W + c; Lj and c from the netlist)
//   - M12: mult bound to M_M12; Spectre multiplicity m follows it
//   - M12: junction geometry ad/as/pd/ps rewritten in terms of the bound width (area = Lj*W, perimeter = 2*W + c; Lj and c from the netlist)
//   - M9: mult bound to M_M9; Spectre multiplicity m follows it
//   - M9: junction geometry ad/as/pd/ps rewritten in terms of the bound width (area = Lj*W, perimeter = 2*W + c; Lj and c from the netlist)
//   - M5_10: mult bound to M_PTAT; Spectre multiplicity m follows it
//   - M5_10: junction geometry ad/as/pd/ps rewritten in terms of the bound width (area = Lj*W, perimeter = 2*W + c; Lj and c from the netlist)
//   - M5_9: mult bound to M_PTAT; Spectre multiplicity m follows it
//   - M5_9: junction geometry ad/as/pd/ps rewritten in terms of the bound width (area = Lj*W, perimeter = 2*W + c; Lj and c from the netlist)
//   - M5_8: mult bound to M_PTAT; Spectre multiplicity m follows it
//   - M5_8: junction geometry ad/as/pd/ps rewritten in terms of the bound width (area = Lj*W, perimeter = 2*W + c; Lj and c from the netlist)
//   - M5_7: mult bound to M_PTAT; Spectre multiplicity m follows it
//   - M5_7: junction geometry ad/as/pd/ps rewritten in terms of the bound width (area = Lj*W, perimeter = 2*W + c; Lj and c from the netlist)
//   - M5_6: mult bound to M_PTAT; Spectre multiplicity m follows it
//   - M5_6: junction geometry ad/as/pd/ps rewritten in terms of the bound width (area = Lj*W, perimeter = 2*W + c; Lj and c from the netlist)
//   - M5_5: mult bound to M_PTAT; Spectre multiplicity m follows it
//   - M5_5: junction geometry ad/as/pd/ps rewritten in terms of the bound width (area = Lj*W, perimeter = 2*W + c; Lj and c from the netlist)
//   - M5_4: mult bound to M_PTAT; Spectre multiplicity m follows it
//   - M5_4: junction geometry ad/as/pd/ps rewritten in terms of the bound width (area = Lj*W, perimeter = 2*W + c; Lj and c from the netlist)
//   - M5_3: mult bound to M_PTAT; Spectre multiplicity m follows it
//   - M5_3: junction geometry ad/as/pd/ps rewritten in terms of the bound width (area = Lj*W, perimeter = 2*W + c; Lj and c from the netlist)
//   - M5_2: mult bound to M_PTAT; Spectre multiplicity m follows it
//   - M5_2: junction geometry ad/as/pd/ps rewritten in terms of the bound width (area = Lj*W, perimeter = 2*W + c; Lj and c from the netlist)
//   - M5_1: mult bound to M_PTAT; Spectre multiplicity m follows it
//   - M5_1: junction geometry ad/as/pd/ps rewritten in terms of the bound width (area = Lj*W, perimeter = 2*W + c; Lj and c from the netlist)
//   - M4: mult bound to M_M4; Spectre multiplicity m follows it
//   - M4: junction geometry ad/as/pd/ps rewritten in terms of the bound width (area = Lj*W, perimeter = 2*W + c; Lj and c from the netlist)
//   - netlist parameters bound to sizing variables: W_M10 <- W_M10, W_M11 <- W_M11, W_M12 <- W_M12, W_M13 <- W_M13, W_M4 <- W_M4, W_M8 <- W_M8, W_M9 <- W_M9, W_PBIAS <- W_PBIAS, W_PMIR <- W_PMIR, W_PTAT <- W_PTAT
subckt bgr_fig3_paper (GND VDD VREF)
parameters W_PMIR=1e-06 L_PMIR=1e-06 W_PTAT=1e-06 L_PTAT=1e-06 W_M4=1e-06 L_M4=1e-06 W_PBIAS=1e-06 L_PBIAS=1e-06 W_M8=1e-06 L_M8=1e-06 W_M9=1e-06 L_M9=1e-06 W_M10=1e-06 W_M11=1e-06 L_PIN=1e-06 W_M12=1e-06 W_M13=1e-06 L_NLD=1e-06 R1=10000.0 R2=10000.0 R3=10000.0 R4=10000.0 CC=1e-12 M_PMIR=1.0 NF_PMIR=1.0 M_PTAT=1.0 NF_PTAT=1.0 M_M4=1.0 NF_M4=1.0 M_PBIAS=1.0 NF_PBIAS=1.0 M_M8=1.0 NF_M8=1.0 M_M9=1.0 NF_M9=1.0 M_M10=1.0 NF_M10=1.0 M_M11=1.0 NF_M11=1.0 M_M12=1.0 NF_M12=1.0 M_M13=1.0 NF_M13=1.0
M11 (N2 VINP TAIL VDD) sky130_fd_pr__pfet_01v8 w=((W_M11*NF_M11)/1e-06) l=(L_PIN/1e-06) nf=NF_M11 mult=M_M11 ad=(0.2899999999998838*(((W_M11*NF_M11)/1e-06))) as=(0.2899999999998838*(((W_M11*NF_M11)/1e-06))) pd=max(2*(((W_M11*NF_M11)/1e-06))+(0.5799999999999983),0) ps=max(2*(((W_M11*NF_M11)/1e-06))+(0.5799999999999983),0) sa=0 sb=0 sd=0 m=M_M11
M10 (N1 VINN TAIL VDD) sky130_fd_pr__pfet_01v8 w=((W_M10*NF_M10)/1e-06) l=(L_PIN/1e-06) nf=NF_M10 mult=M_M10 ad=(0.2899999999991924*(((W_M10*NF_M10)/1e-06))) as=(0.2899999999991924*(((W_M10*NF_M10)/1e-06))) pd=max(2*(((W_M10*NF_M10)/1e-06))+(0.5799999999000036),0) ps=max(2*(((W_M10*NF_M10)/1e-06))+(0.5799999999000036),0) sa=0 sb=0 sd=0 m=M_M10
M8 (BIAS PB VDD VDD) sky130_fd_pr__pfet_01v8 w=((W_M8*NF_M8)/1e-06) l=(L_M8/1e-06) nf=NF_M8 mult=M_M8 ad=(0.29*(((W_M8*NF_M8)/1e-06))) as=(0.29*(((W_M8*NF_M8)/1e-06))) pd=max(2*(((W_M8*NF_M8)/1e-06))+(0.5799999999999983),0) ps=max(2*(((W_M8*NF_M8)/1e-06))+(0.5799999999999983),0) sa=0 sb=0 sd=0 m=M_M8
M7 (TAIL PB VDD VDD) sky130_fd_pr__pfet_01v8 w=((W_PBIAS*NF_PBIAS)/1e-06) l=(L_PBIAS/1e-06) nf=NF_PBIAS mult=M_PBIAS ad=(0.2900000000003074*(((W_PBIAS*NF_PBIAS)/1e-06))) as=(0.2900000000003074*(((W_PBIAS*NF_PBIAS)/1e-06))) pd=max(2*(((W_PBIAS*NF_PBIAS)/1e-06))+(0.5799999999999983),0) ps=max(2*(((W_PBIAS*NF_PBIAS)/1e-06))+(0.5799999999999983),0) sa=0 sb=0 sd=0 m=M_PBIAS
M6 (PB PB VDD VDD) sky130_fd_pr__pfet_01v8 w=((W_PBIAS*NF_PBIAS)/1e-06) l=(L_PBIAS/1e-06) nf=NF_PBIAS mult=M_PBIAS ad=(0.2900000000003074*(((W_PBIAS*NF_PBIAS)/1e-06))) as=(0.2900000000003074*(((W_PBIAS*NF_PBIAS)/1e-06))) pd=max(2*(((W_PBIAS*NF_PBIAS)/1e-06))+(0.5799999999999983),0) ps=max(2*(((W_PBIAS*NF_PBIAS)/1e-06))+(0.5799999999999983),0) sa=0 sb=0 sd=0 m=M_PBIAS
M3 (VREF BIAS VDD VDD) sky130_fd_pr__pfet_01v8 w=((W_PMIR*NF_PMIR)/1e-06) l=(L_PMIR/1e-06) nf=NF_PMIR mult=M_PMIR ad=(0.2900000000004803*(((W_PMIR*NF_PMIR)/1e-06))) as=(0.2900000000004803*(((W_PMIR*NF_PMIR)/1e-06))) pd=max(2*(((W_PMIR*NF_PMIR)/1e-06))+(0.5800000000200001),0) ps=max(2*(((W_PMIR*NF_PMIR)/1e-06))+(0.5800000000200001),0) sa=0 sb=0 sd=0 m=M_PMIR
M2 (VINP BIAS VDD VDD) sky130_fd_pr__pfet_01v8 w=((W_PMIR*NF_PMIR)/1e-06) l=(L_PMIR/1e-06) nf=NF_PMIR mult=M_PMIR ad=(0.2900000000004803*(((W_PMIR*NF_PMIR)/1e-06))) as=(0.2900000000004803*(((W_PMIR*NF_PMIR)/1e-06))) pd=max(2*(((W_PMIR*NF_PMIR)/1e-06))+(0.5800000000200001),0) ps=max(2*(((W_PMIR*NF_PMIR)/1e-06))+(0.5800000000200001),0) sa=0 sb=0 sd=0 m=M_PMIR
M1 (VINN BIAS VDD VDD) sky130_fd_pr__pfet_01v8 w=((W_PMIR*NF_PMIR)/1e-06) l=(L_PMIR/1e-06) nf=NF_PMIR mult=M_PMIR ad=(0.2900000000004803*(((W_PMIR*NF_PMIR)/1e-06))) as=(0.2900000000004803*(((W_PMIR*NF_PMIR)/1e-06))) pd=max(2*(((W_PMIR*NF_PMIR)/1e-06))+(0.5800000000200001),0) ps=max(2*(((W_PMIR*NF_PMIR)/1e-06))+(0.5800000000200001),0) sa=0 sb=0 sd=0 m=M_PMIR
M13 (N2 N1 GND GND) sky130_fd_pr__nfet_01v8 w=((W_M13*NF_M13)/1e-06) l=(L_NLD/1e-06) nf=NF_M13 mult=M_M13 ad=(0.2899999999994012*(((W_M13*NF_M13)/1e-06))) as=(0.2899999999994012*(((W_M13*NF_M13)/1e-06))) pd=max(2*(((W_M13*NF_M13)/1e-06))+(0.5799999999900001),0) ps=max(2*(((W_M13*NF_M13)/1e-06))+(0.5799999999900001),0) sa=0 sb=0 sd=0 m=M_M13
M12 (N1 N1 GND GND) sky130_fd_pr__nfet_01v8 w=((W_M12*NF_M12)/1e-06) l=(L_NLD/1e-06) nf=NF_M12 mult=M_M12 ad=(0.28999999999935416*(((W_M12*NF_M12)/1e-06))) as=(0.28999999999935416*(((W_M12*NF_M12)/1e-06))) pd=max(2*(((W_M12*NF_M12)/1e-06))+(0.5799999999900001),0) ps=max(2*(((W_M12*NF_M12)/1e-06))+(0.5799999999900001),0) sa=0 sb=0 sd=0 m=M_M12
M9 (BIAS N2 GND GND) sky130_fd_pr__nfet_01v8 w=((W_M9*NF_M9)/1e-06) l=(L_M9/1e-06) nf=NF_M9 mult=M_M9 ad=(0.29*(((W_M9*NF_M9)/1e-06))) as=(0.29*(((W_M9*NF_M9)/1e-06))) pd=max(2*(((W_M9*NF_M9)/1e-06))+(0.5800000000000125),0) ps=max(2*(((W_M9*NF_M9)/1e-06))+(0.5800000000000125),0) sa=0 sb=0 sd=0 m=M_M9
M5_10 (PTAT PTAT GND GND) sky130_fd_pr__nfet_01v8 w=((W_PTAT*NF_PTAT)/1e-06) l=(L_PTAT/1e-06) nf=NF_PTAT mult=M_PTAT ad=(0.29000000000053133*(((W_PTAT*NF_PTAT)/1e-06))) as=(0.29000000000053133*(((W_PTAT*NF_PTAT)/1e-06))) pd=max(2*(((W_PTAT*NF_PTAT)/1e-06))+(0.5800000001000001),0) ps=max(2*(((W_PTAT*NF_PTAT)/1e-06))+(0.5800000001000001),0) sa=0 sb=0 sd=0 m=M_PTAT
M5_9 (PTAT PTAT GND GND) sky130_fd_pr__nfet_01v8 w=((W_PTAT*NF_PTAT)/1e-06) l=(L_PTAT/1e-06) nf=NF_PTAT mult=M_PTAT ad=(0.29000000000053133*(((W_PTAT*NF_PTAT)/1e-06))) as=(0.29000000000053133*(((W_PTAT*NF_PTAT)/1e-06))) pd=max(2*(((W_PTAT*NF_PTAT)/1e-06))+(0.5800000001000001),0) ps=max(2*(((W_PTAT*NF_PTAT)/1e-06))+(0.5800000001000001),0) sa=0 sb=0 sd=0 m=M_PTAT
M5_8 (PTAT PTAT GND GND) sky130_fd_pr__nfet_01v8 w=((W_PTAT*NF_PTAT)/1e-06) l=(L_PTAT/1e-06) nf=NF_PTAT mult=M_PTAT ad=(0.29000000000053133*(((W_PTAT*NF_PTAT)/1e-06))) as=(0.29000000000053133*(((W_PTAT*NF_PTAT)/1e-06))) pd=max(2*(((W_PTAT*NF_PTAT)/1e-06))+(0.5800000001000001),0) ps=max(2*(((W_PTAT*NF_PTAT)/1e-06))+(0.5800000001000001),0) sa=0 sb=0 sd=0 m=M_PTAT
M5_7 (PTAT PTAT GND GND) sky130_fd_pr__nfet_01v8 w=((W_PTAT*NF_PTAT)/1e-06) l=(L_PTAT/1e-06) nf=NF_PTAT mult=M_PTAT ad=(0.29000000000053133*(((W_PTAT*NF_PTAT)/1e-06))) as=(0.29000000000053133*(((W_PTAT*NF_PTAT)/1e-06))) pd=max(2*(((W_PTAT*NF_PTAT)/1e-06))+(0.5800000001000001),0) ps=max(2*(((W_PTAT*NF_PTAT)/1e-06))+(0.5800000001000001),0) sa=0 sb=0 sd=0 m=M_PTAT
M5_6 (PTAT PTAT GND GND) sky130_fd_pr__nfet_01v8 w=((W_PTAT*NF_PTAT)/1e-06) l=(L_PTAT/1e-06) nf=NF_PTAT mult=M_PTAT ad=(0.29000000000053133*(((W_PTAT*NF_PTAT)/1e-06))) as=(0.29000000000053133*(((W_PTAT*NF_PTAT)/1e-06))) pd=max(2*(((W_PTAT*NF_PTAT)/1e-06))+(0.5800000001000001),0) ps=max(2*(((W_PTAT*NF_PTAT)/1e-06))+(0.5800000001000001),0) sa=0 sb=0 sd=0 m=M_PTAT
M5_5 (PTAT PTAT GND GND) sky130_fd_pr__nfet_01v8 w=((W_PTAT*NF_PTAT)/1e-06) l=(L_PTAT/1e-06) nf=NF_PTAT mult=M_PTAT ad=(0.29000000000053133*(((W_PTAT*NF_PTAT)/1e-06))) as=(0.29000000000053133*(((W_PTAT*NF_PTAT)/1e-06))) pd=max(2*(((W_PTAT*NF_PTAT)/1e-06))+(0.5800000001000001),0) ps=max(2*(((W_PTAT*NF_PTAT)/1e-06))+(0.5800000001000001),0) sa=0 sb=0 sd=0 m=M_PTAT
M5_4 (PTAT PTAT GND GND) sky130_fd_pr__nfet_01v8 w=((W_PTAT*NF_PTAT)/1e-06) l=(L_PTAT/1e-06) nf=NF_PTAT mult=M_PTAT ad=(0.29000000000053133*(((W_PTAT*NF_PTAT)/1e-06))) as=(0.29000000000053133*(((W_PTAT*NF_PTAT)/1e-06))) pd=max(2*(((W_PTAT*NF_PTAT)/1e-06))+(0.5800000001000001),0) ps=max(2*(((W_PTAT*NF_PTAT)/1e-06))+(0.5800000001000001),0) sa=0 sb=0 sd=0 m=M_PTAT
M5_3 (PTAT PTAT GND GND) sky130_fd_pr__nfet_01v8 w=((W_PTAT*NF_PTAT)/1e-06) l=(L_PTAT/1e-06) nf=NF_PTAT mult=M_PTAT ad=(0.29000000000053133*(((W_PTAT*NF_PTAT)/1e-06))) as=(0.29000000000053133*(((W_PTAT*NF_PTAT)/1e-06))) pd=max(2*(((W_PTAT*NF_PTAT)/1e-06))+(0.5800000001000001),0) ps=max(2*(((W_PTAT*NF_PTAT)/1e-06))+(0.5800000001000001),0) sa=0 sb=0 sd=0 m=M_PTAT
M5_2 (PTAT PTAT GND GND) sky130_fd_pr__nfet_01v8 w=((W_PTAT*NF_PTAT)/1e-06) l=(L_PTAT/1e-06) nf=NF_PTAT mult=M_PTAT ad=(0.29000000000053133*(((W_PTAT*NF_PTAT)/1e-06))) as=(0.29000000000053133*(((W_PTAT*NF_PTAT)/1e-06))) pd=max(2*(((W_PTAT*NF_PTAT)/1e-06))+(0.5800000001000001),0) ps=max(2*(((W_PTAT*NF_PTAT)/1e-06))+(0.5800000001000001),0) sa=0 sb=0 sd=0 m=M_PTAT
M5_1 (PTAT PTAT GND GND) sky130_fd_pr__nfet_01v8 w=((W_PTAT*NF_PTAT)/1e-06) l=(L_PTAT/1e-06) nf=NF_PTAT mult=M_PTAT ad=(0.29000000000053133*(((W_PTAT*NF_PTAT)/1e-06))) as=(0.29000000000053133*(((W_PTAT*NF_PTAT)/1e-06))) pd=max(2*(((W_PTAT*NF_PTAT)/1e-06))+(0.5800000001000001),0) ps=max(2*(((W_PTAT*NF_PTAT)/1e-06))+(0.5800000001000001),0) sa=0 sb=0 sd=0 m=M_PTAT
M4 (VINN VINN GND GND) sky130_fd_pr__nfet_01v8 w=((W_M4*NF_M4)/1e-06) l=(L_M4/1e-06) nf=NF_M4 mult=M_M4 ad=(0.2900000000004336*(((W_M4*NF_M4)/1e-06))) as=(0.2900000000004336*(((W_M4*NF_M4)/1e-06))) pd=max(2*(((W_M4*NF_M4)/1e-06))+(0.5800000001000001),0) ps=max(2*(((W_M4*NF_M4)/1e-06))+(0.5800000001000001),0) sa=0 sb=0 sd=0 m=M_M4
R4 (PB GND) resistor r=R4
R3 (VREF GND) resistor r=R3
R2 (VINP GND) resistor r=R2
R1 (VINP PTAT) resistor r=R1
CC (N2 BIAS) capacitor c=CC
ends bgr_fig3_paper
