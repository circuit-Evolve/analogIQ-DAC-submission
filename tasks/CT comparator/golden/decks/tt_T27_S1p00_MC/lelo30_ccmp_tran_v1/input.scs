// analogiq 0.1.0 testbench - generated, do not edit
// task ccmp_lelo_task_001  topology ccmp_lelo
// recipe lelo30_ccmp_tran_v1 v1  condition tt_T27_S1p00_MC (Monte Carlo mismatch, 20 samples, seed 1; models tt, 27 C, supply 1.8 V)
// request golden_ccmp_lelo_task_001  candidate fa1c951ba4472c00
// execution profile search_full
simulator lang=spectre
global 0
include "<WORK>/analogiq/pdk_overlays/sky130_mm/sky130_mm.lib.spice" section=tt_mm
include "dut.scs"

parameters vc=0.75 ibias=1e-06 vsup=1.8 vneg=0.0
// Supplies (charged to the DUT power metrics).
VSUP (vdd 0) vsource dc=vsup
VNEG (vss 0) vsource dc=vneg
// External bias (topology external_bias; reported separately as bias power).
VB_PWRUP_B_1V8 (vdd b_PWRUP_B_1V8) vsource dc=0.0
VB_PWRUP_N_1V8 (b_PWRUP_N_1V8 0) vsource dc=0.0
IB_IBP_1U_1 (vdd b_IBP_1U_1) isource dc=1e-06

VRST (rst 0) vsource type=pwl wave=[0 1.8 2e-07 1.8 2.001e-07 0]
VC (inn 0) vsource dc=vc
// IRAMP: the ramp current charges the integrating node (repository tran.spi IRAMP VDD_1V8 IBP_1U<0>)
IRAMP (vdd inp) isource dc=ibias

XDUT (vdd b_PWRUP_B_1V8 b_PWRUP_N_1V8 vss b_IBP_1U_1 inp outp inn rst) ccmp_lelo_dut L_BIAS=9.4e-07 L_CAP=5e-06 L_CS=2.2e-07 L_DIFF=2.2e-07 L_NLOAD=9.4e-07 L_PTAIL=9.4e-07 L_RST=9.4e-07 NF_BIAS=2.0 NF_CS=2.0 NF_DIFF=2.0 NF_NLOAD=2.0 NF_PTAIL=2.0 NF_RST=2.0 W_BIAS=9.6e-07 W_CAP=5e-06 W_CS=9.6e-07 W_DIFF=9.6e-07 W_NLOAD=9.6e-07 W_PTAIL=9.6e-07 W_RST=9.6e-07

opts options temp=27.0 tnom=27 reltol=0.0001 save=selected
save VB_PWRUP_B_1V8:p VB_PWRUP_N_1V8:p VNEG:p VSUP:p inn inp outp rst vdd vss

mcsamp montecarlo numruns=20 seed=1 variations=mismatch savefamilyplots=yes donominal=no {
tran1 tran stop=6e-07 maxstep=1e-10 errpreset=moderate
}
