// Golden sizing netlist (curator 2026-10-28): the benchmark DUT subckt with its parameter defaults set to
// the golden design (golden_design.json), taken from the verified run's job tt_T27_S1p00/lelo30_ccmp_op_v1.
// The DUT subckt and its parameter values are the same in every job of that run (only the testbench changes).
// Instance line of that run: XDUT (vdd b_PWRUP_B_1V8 b_PWRUP_N_1V8 vss b_IBP_1U_1 inp outp inn rst) ccmp_lelo_dut L_BIAS=9.4e-07 L_CAP=5e-06 L_CS=2.2e-07 L_DIFF=2.2e-07 L_NLOAD=9.4e-07 L_PTAIL=9.4e-07 L_RST=9.4e-07 NF_BIAS=2.0 NF...
// Testbench-level variables (bias sources, operating levels) are in golden_design.json and testbench decks.
// Generated by analogiq from dut_benchmark.scs (sha256 769e34614c9399bf).
// Connectivity and device models are unchanged except for the listed transformations:
//   - xg1_M1: junction geometry ad/as/pd/ps rewritten in terms of the bound width (area = Lj*W, perimeter = 2*W + c; Lj and c from the netlist)
//   - x1_cmp_xn_mirr_load2_M1: junction geometry ad/as/pd/ps rewritten in terms of the bound width (area = Lj*W, perimeter = 2*W + c; Lj and c from the netlist)
//   - x1_cmp_xn_mirr_load3_M1: junction geometry ad/as/pd/ps rewritten in terms of the bound width (area = Lj*W, perimeter = 2*W + c; Lj and c from the netlist)
//   - x1_cmp_xp_mirr_tail2_M1: junction geometry ad/as/pd/ps rewritten in terms of the bound width (area = Lj*W, perimeter = 2*W + c; Lj and c from the netlist)
//   - x1_cmp_xn_mirr_load5_M1: junction geometry ad/as/pd/ps rewritten in terms of the bound width (area = Lj*W, perimeter = 2*W + c; Lj and c from the netlist)
//   - x1_cmp_xn_mirr_bias1_M1: junction geometry ad/as/pd/ps rewritten in terms of the bound width (area = Lj*W, perimeter = 2*W + c; Lj and c from the netlist)
//   - x1_cmp_xn_mirr_bias2_M1: junction geometry ad/as/pd/ps rewritten in terms of the bound width (area = Lj*W, perimeter = 2*W + c; Lj and c from the netlist)
//   - x1_cmp_xp_mirr_tail1_M1: junction geometry ad/as/pd/ps rewritten in terms of the bound width (area = Lj*W, perimeter = 2*W + c; Lj and c from the netlist)
//   - x1_cmp_xp_mirr_tail3_M1: junction geometry ad/as/pd/ps rewritten in terms of the bound width (area = Lj*W, perimeter = 2*W + c; Lj and c from the netlist)
//   - x1_cmp_xp_diff2_M1: junction geometry ad/as/pd/ps rewritten in terms of the bound width (area = Lj*W, perimeter = 2*W + c; Lj and c from the netlist)
//   - x1_cmp_xp_diff1_M1: junction geometry ad/as/pd/ps rewritten in terms of the bound width (area = Lj*W, perimeter = 2*W + c; Lj and c from the netlist)
//   - netlist parameters bound to sizing variables: W_BIAS <- W_BIAS, W_CS <- W_CS, W_DIFF <- W_DIFF, W_NLOAD <- W_NLOAD, W_PTAIL <- W_PTAIL, W_RST <- W_RST
subckt ccmp_lelo_dut (VDD_1V8 PWRUP_B_1V8 PWRUP_N_1V8 VSS IBP_1U_1 IBP_1U_0 CMPO VC RST)
parameters W_DIFF=9.6e-07 L_DIFF=2.2e-07 NF_DIFF=2.0 W_PTAIL=9.6e-07 L_PTAIL=9.4e-07 NF_PTAIL=2.0 W_NLOAD=9.6e-07 L_NLOAD=9.4e-07 NF_NLOAD=2.0 W_CS=9.6e-07 L_CS=2.2e-07 NF_CS=2.0 W_BIAS=9.6e-07 L_BIAS=9.4e-07 NF_BIAS=2.0 W_RST=9.6e-07 L_RST=9.4e-07 NF_RST=2.0 W_CAP=5e-06 L_CAP=5e-06
xd1_C1 (VSS IBP_1U_0) sky130_fd_pr__cap_mim_m3_1 w=(W_CAP/1e-06) l=(L_CAP/1e-06) mult=5.0 m=5.0
xg1_M1 (IBP_1U_0 RST VSS VSS) sky130_fd_pr__nfet_01v8 w=((W_RST*NF_RST)/1e-06) l=(L_RST/1e-06) nf=NF_RST mult=1.0 ad=(0.145*(((W_RST*NF_RST)/1e-06))) as=(0.29*(((W_RST*NF_RST)/1e-06))) pd=max(2*(((W_RST*NF_RST)/1e-06))+(-1.3399999999999999),0) ps=max(2*(((W_RST*NF_RST)/1e-06))+(1.1600000000000001),0) sa=0 sb=0 sd=0 m=1.0
x1_cmp_xn_mirr_load2_M1 (x1_cmp_VBN1 x1_cmp_VBN1 VSS VSS) sky130_fd_pr__nfet_01v8 w=((W_NLOAD*NF_NLOAD)/1e-06) l=(L_NLOAD/1e-06) nf=NF_NLOAD mult=1.0 ad=(0.145*(((W_NLOAD*NF_NLOAD)/1e-06))) as=(0.29*(((W_NLOAD*NF_NLOAD)/1e-06))) pd=max(2*(((W_NLOAD*NF_NLOAD)/1e-06))+(-1.3399999999999999),0) ps=max(2*(((W_NLOAD*NF_NLOAD)/1e-06))+(1.1600000000000001),0) sa=0 sb=0 sd=0 m=1.0
x1_cmp_xn_mirr_load3_M1 (x1_cmp_VO1 x1_cmp_VBN1 VSS VSS) sky130_fd_pr__nfet_01v8 w=((W_NLOAD*NF_NLOAD)/1e-06) l=(L_NLOAD/1e-06) nf=NF_NLOAD mult=1.0 ad=(0.145*(((W_NLOAD*NF_NLOAD)/1e-06))) as=(0.29*(((W_NLOAD*NF_NLOAD)/1e-06))) pd=max(2*(((W_NLOAD*NF_NLOAD)/1e-06))+(-1.3399999999999999),0) ps=max(2*(((W_NLOAD*NF_NLOAD)/1e-06))+(1.1600000000000001),0) sa=0 sb=0 sd=0 m=1.0
x1_cmp_xp_mirr_tail2_M1 (CMPO x1_cmp_VBP2 VDD_1V8 VDD_1V8) sky130_fd_pr__pfet_01v8 w=((W_PTAIL*NF_PTAIL)/1e-06) l=(L_PTAIL/1e-06) nf=NF_PTAIL mult=1.0 ad=(0.145*(((W_PTAIL*NF_PTAIL)/1e-06))) as=(0.29*(((W_PTAIL*NF_PTAIL)/1e-06))) pd=max(2*(((W_PTAIL*NF_PTAIL)/1e-06))+(-1.3399999999999999),0) ps=max(2*(((W_PTAIL*NF_PTAIL)/1e-06))+(1.1600000000000001),0) sa=0 sb=0 sd=0 m=1.0
x1_cmp_xn_mirr_load5_M1 (CMPO x1_cmp_VO1 VSS VSS) sky130_fd_pr__nfet_01v8 w=((W_CS*NF_CS)/1e-06) l=(L_CS/1e-06) nf=NF_CS mult=1.0 ad=(0.145*(((W_CS*NF_CS)/1e-06))) as=(0.29*(((W_CS*NF_CS)/1e-06))) pd=max(2*(((W_CS*NF_CS)/1e-06))+(-1.3399999999999999),0) ps=max(2*(((W_CS*NF_CS)/1e-06))+(1.1600000000000001),0) sa=0 sb=0 sd=0 m=1.0
x1_cmp_xp_mirr_tail1_0__M1 (x1_cmp_VBP2 PWRUP_B_1V8 VDD_1V8 VDD_1V8) sky130_fd_pr__pfet_01v8 w=1.92 l=0.94 nf=2 mult=1.0 ad=0.2784 as=0.5568 pd=2.5 ps=5 sa=0 sb=0 sd=0 m=1.0
x1_cmp_xn_mirr_load1_M1 (x1_cmp_VBN1 PWRUP_N_1V8 VSS VSS) sky130_fd_pr__nfet_01v8 w=1.92 l=0.94 nf=2 mult=1.0 ad=0.2784 as=0.5568 pd=2.5 ps=5 sa=0 sb=0 sd=0 m=1.0
x1_cmp_xn_mirr_load4_M1 (CMPO PWRUP_N_1V8 VSS VSS) sky130_fd_pr__nfet_01v8 w=1.92 l=0.94 nf=2 mult=1.0 ad=0.2784 as=0.5568 pd=2.5 ps=5 sa=0 sb=0 sd=0 m=1.0
x1_cmp_xn_mirr_bias1_M1 (IBP_1U_1 IBP_1U_1 VSS VSS) sky130_fd_pr__nfet_01v8 w=((W_BIAS*NF_BIAS)/1e-06) l=(L_BIAS/1e-06) nf=NF_BIAS mult=1.0 ad=(0.145*(((W_BIAS*NF_BIAS)/1e-06))) as=(0.29*(((W_BIAS*NF_BIAS)/1e-06))) pd=max(2*(((W_BIAS*NF_BIAS)/1e-06))+(-1.3399999999999999),0) ps=max(2*(((W_BIAS*NF_BIAS)/1e-06))+(1.1600000000000001),0) sa=0 sb=0 sd=0 m=1.0
x1_cmp_xn_mirr_bias2_M1 (x1_cmp_VBP2 IBP_1U_1 VSS VSS) sky130_fd_pr__nfet_01v8 w=((W_BIAS*NF_BIAS)/1e-06) l=(L_BIAS/1e-06) nf=NF_BIAS mult=4.0 ad=(0.145*(((W_BIAS*NF_BIAS)/1e-06))) as=(0.29*(((W_BIAS*NF_BIAS)/1e-06))) pd=max(2*(((W_BIAS*NF_BIAS)/1e-06))+(-1.3399999999999999),0) ps=max(2*(((W_BIAS*NF_BIAS)/1e-06))+(1.1600000000000001),0) sa=0 sb=0 sd=0 m=4.0
x1_cmp_xn_mirr_bias3_M1 (IBP_1U_1 PWRUP_N_1V8 VSS VSS) sky130_fd_pr__nfet_01v8 w=1.92 l=0.94 nf=2 mult=1.0 ad=0.2784 as=0.5568 pd=2.5 ps=5 sa=0 sb=0 sd=0 m=1.0
x1_cmp_xp_mirr_tail1_M1 (x1_cmp_VBP2 x1_cmp_VBP2 VDD_1V8 VDD_1V8) sky130_fd_pr__pfet_01v8 w=((W_PTAIL*NF_PTAIL)/1e-06) l=(L_PTAIL/1e-06) nf=NF_PTAIL mult=1.0 ad=(0.145*(((W_PTAIL*NF_PTAIL)/1e-06))) as=(0.29*(((W_PTAIL*NF_PTAIL)/1e-06))) pd=max(2*(((W_PTAIL*NF_PTAIL)/1e-06))+(-1.3399999999999999),0) ps=max(2*(((W_PTAIL*NF_PTAIL)/1e-06))+(1.1600000000000001),0) sa=0 sb=0 sd=0 m=1.0
x1_cmp_xp_mirr_tail3_M1 (x1_cmp_VS x1_cmp_VBP2 VDD_1V8 VDD_1V8) sky130_fd_pr__pfet_01v8 w=((W_PTAIL*NF_PTAIL)/1e-06) l=(L_PTAIL/1e-06) nf=NF_PTAIL mult=3.0 ad=(0.145*(((W_PTAIL*NF_PTAIL)/1e-06))) as=(0.29*(((W_PTAIL*NF_PTAIL)/1e-06))) pd=max(2*(((W_PTAIL*NF_PTAIL)/1e-06))+(-1.3399999999999999),0) ps=max(2*(((W_PTAIL*NF_PTAIL)/1e-06))+(1.1600000000000001),0) sa=0 sb=0 sd=0 m=3.0
x1_cmp_xp_diff2_M1 (x1_cmp_VO1 IBP_1U_0 x1_cmp_VS VDD_1V8) sky130_fd_pr__pfet_01v8 w=((W_DIFF*NF_DIFF)/1e-06) l=(L_DIFF/1e-06) nf=NF_DIFF mult=1.0 ad=(0.145*(((W_DIFF*NF_DIFF)/1e-06))) as=(0.29*(((W_DIFF*NF_DIFF)/1e-06))) pd=max(2*(((W_DIFF*NF_DIFF)/1e-06))+(-1.3399999999999999),0) ps=max(2*(((W_DIFF*NF_DIFF)/1e-06))+(1.1600000000000001),0) sa=0 sb=0 sd=0 m=1.0
x1_cmp_xp_diff1_M1 (x1_cmp_VBN1 VC x1_cmp_VS VDD_1V8) sky130_fd_pr__pfet_01v8 w=((W_DIFF*NF_DIFF)/1e-06) l=(L_DIFF/1e-06) nf=NF_DIFF mult=1.0 ad=(0.145*(((W_DIFF*NF_DIFF)/1e-06))) as=(0.29*(((W_DIFF*NF_DIFF)/1e-06))) pd=max(2*(((W_DIFF*NF_DIFF)/1e-06))+(-1.3399999999999999),0) ps=max(2*(((W_DIFF*NF_DIFF)/1e-06))+(1.1600000000000001),0) sa=0 sb=0 sd=0 m=1.0
x1_cmp_xp_diff3_M1 (VDD_1V8 VDD_1V8 VDD_1V8 VDD_1V8) sky130_fd_pr__pfet_01v8 w=1.92 l=0.22 nf=2 mult=4.0 ad=0.2784 as=0.5568 pd=2.5 ps=5 sa=0 sb=0 sd=0 m=4.0
x1_cmp_xn_mirr_load0_M1 (VSS VSS VSS VSS) sky130_fd_pr__nfet_01v8 w=1.92 l=0.94 nf=2 mult=1.0 ad=0.2784 as=0.5568 pd=2.5 ps=5 sa=0 sb=0 sd=0 m=1.0
xg4_M1 (IBP_1U_0 PWRUP_N_1V8 VSS VSS) sky130_fd_pr__nfet_01v8 w=1.92 l=0.94 nf=2 mult=1.0 ad=0.2784 as=0.5568 pd=2.5 ps=5 sa=0 sb=0 sd=0 m=1.0
ends ccmp_lelo_dut
