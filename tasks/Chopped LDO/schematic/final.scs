simulator lang=spice
.lib "<PDK_ROOT>/sky130_cds/spectre/libs.tech/combined/sky130.lib.spice" tt
simulator lang=spectre
subckt infineon_ldo_transistor (clk_i disable_i ibp_1u_ai overvoltage_o undervoltage_o vout_1V5_ao vref_ai inh_bulkn inh_bulkpanalog inh_hsupanalog inh_lSup)
M00000 (N00012 N00013 inh_hsupanalog inh_bulkpanalog) sky130_fd_pr__pfet_g5v0d10v5 w=2.875 l=0.5 nf=1 mult=1 ad=0.83375 as=0.83375 pd=6.33 ps=6.33 sa=0 sb=0 sd=0 m=1
M00001 (N00013 N00014 inh_hsupanalog inh_bulkpanalog) sky130_fd_pr__pfet_g5v0d10v5 w=2.875 l=0.5 nf=1 mult=1 ad=0.83375 as=0.83375 pd=6.33 ps=6.33 sa=0 sb=0 sd=0 m=1
M00002 (N00013 N00015 inh_hsupanalog inh_bulkpanalog) sky130_fd_pr__pfet_g5v0d10v5 w=2.875 l=0.5 nf=1 mult=1 ad=0.83375 as=0.83375 pd=6.33 ps=6.33 sa=0 sb=0 sd=0 m=1
M00003 (N00012 N00013 inh_lSup inh_lSup) sky130_fd_pr__nfet_g5v0d10v5 w=0.625 l=0.5 nf=1 mult=1 ad=0.18125 as=0.18125 pd=1.83 ps=1.83 sa=0 sb=0 sd=0 m=1
M00004 (N00013 N00014 N00016 inh_lSup) sky130_fd_pr__nfet_g5v0d10v5 w=0.625 l=0.5 nf=1 mult=1 ad=0.18125 as=0.18125 pd=1.83 ps=1.83 sa=0 sb=0 sd=0 m=1
M00005 (N00016 N00015 inh_lSup inh_lSup) sky130_fd_pr__nfet_g5v0d10v5 w=0.625 l=0.5 nf=1 mult=1 ad=0.18125 as=0.18125 pd=1.83 ps=1.83 sa=0 sb=0 sd=0 m=1
D00006 (inh_lSup inh_hsupanalog) sky130_fd_pr__diode_pd2nw_05v5 area=1 perim=4 mult=1 m=1
M00007 (N00017 N00018 inh_hsupanalog inh_bulkpanalog) sky130_fd_pr__pfet_g5v0d10v5 w=2.875 l=0.5 nf=1 mult=1 ad=0.83375 as=0.83375 pd=6.33 ps=6.33 sa=0 sb=0 sd=0 m=1
M00008 (N00018 N00019 inh_hsupanalog inh_bulkpanalog) sky130_fd_pr__pfet_g5v0d10v5 w=2.875 l=0.5 nf=1 mult=1 ad=0.83375 as=0.83375 pd=6.33 ps=6.33 sa=0 sb=0 sd=0 m=1
M00009 (N00018 N00015 inh_hsupanalog inh_bulkpanalog) sky130_fd_pr__pfet_g5v0d10v5 w=2.875 l=0.5 nf=1 mult=1 ad=0.83375 as=0.83375 pd=6.33 ps=6.33 sa=0 sb=0 sd=0 m=1
M00010 (N00017 N00018 inh_lSup inh_lSup) sky130_fd_pr__nfet_g5v0d10v5 w=0.625 l=0.5 nf=1 mult=1 ad=0.18125 as=0.18125 pd=1.83 ps=1.83 sa=0 sb=0 sd=0 m=1
M00011 (N00018 N00019 N00020 inh_lSup) sky130_fd_pr__nfet_g5v0d10v5 w=0.625 l=0.5 nf=1 mult=1 ad=0.18125 as=0.18125 pd=1.83 ps=1.83 sa=0 sb=0 sd=0 m=1
M00012 (N00020 N00015 inh_lSup inh_lSup) sky130_fd_pr__nfet_g5v0d10v5 w=0.625 l=0.5 nf=1 mult=1 ad=0.18125 as=0.18125 pd=1.83 ps=1.83 sa=0 sb=0 sd=0 m=1
D00013 (inh_lSup inh_hsupanalog) sky130_fd_pr__diode_pd2nw_05v5 area=1 perim=4 mult=1 m=1
M00014 (N00021 inh_lSup N00022 inh_bulkpanalog) sky130_fd_pr__pfet_g5v0d10v5 w=2.875 l=0.5 nf=1 mult=1 ad=0.83375 as=0.83375 pd=6.33 ps=6.33 sa=0 sb=0 sd=0 m=1
M00015 (N00021 inh_hsupanalog N00022 inh_lSup) sky130_fd_pr__nfet_g5v0d10v5 w=0.625 l=0.5 nf=1 mult=1 ad=0.18125 as=0.18125 pd=1.83 ps=1.83 sa=0 sb=0 sd=0 m=1
M00016 (N00023 N00017 inh_hsupanalog inh_bulkpanalog) sky130_fd_pr__pfet_g5v0d10v5 w=2.875 l=0.5 nf=1 mult=1 ad=0.83375 as=0.83375 pd=6.33 ps=6.33 sa=0 sb=0 sd=0 m=1
M00017 (N00023 N00017 inh_lSup inh_lSup) sky130_fd_pr__nfet_g5v0d10v5 w=0.625 l=0.5 nf=1 mult=1 ad=0.18125 as=0.18125 pd=1.83 ps=1.83 sa=0 sb=0 sd=0 m=1
D00018 (inh_lSup inh_hsupanalog) sky130_fd_pr__diode_pd2nw_05v5 area=1 perim=4 mult=1 m=1
M00019 (N00024 N00023 inh_hsupanalog inh_bulkpanalog) sky130_fd_pr__pfet_g5v0d10v5 w=2.875 l=0.5 nf=1 mult=1 ad=0.83375 as=0.83375 pd=6.33 ps=6.33 sa=0 sb=0 sd=0 m=1
M00020 (N00024 N00023 inh_lSup inh_lSup) sky130_fd_pr__nfet_g5v0d10v5 w=0.625 l=0.5 nf=1 mult=1 ad=0.18125 as=0.18125 pd=1.83 ps=1.83 sa=0 sb=0 sd=0 m=1
D00021 (inh_lSup inh_hsupanalog) sky130_fd_pr__diode_pd2nw_05v5 area=1 perim=4 mult=1 m=1
M00022 (N00025 N00024 inh_hsupanalog inh_bulkpanalog) sky130_fd_pr__pfet_g5v0d10v5 w=2.875 l=0.5 nf=1 mult=1 ad=0.83375 as=0.83375 pd=6.33 ps=6.33 sa=0 sb=0 sd=0 m=1
M00023 (N00025 N00024 inh_lSup inh_lSup) sky130_fd_pr__nfet_g5v0d10v5 w=0.625 l=0.5 nf=1 mult=1 ad=0.18125 as=0.18125 pd=1.83 ps=1.83 sa=0 sb=0 sd=0 m=1
D00024 (inh_lSup inh_hsupanalog) sky130_fd_pr__diode_pd2nw_05v5 area=1 perim=4 mult=1 m=1
M00025 (N00026 N00022 inh_hsupanalog inh_bulkpanalog) sky130_fd_pr__pfet_g5v0d10v5 w=2.875 l=0.5 nf=1 mult=1 ad=0.83375 as=0.83375 pd=6.33 ps=6.33 sa=0 sb=0 sd=0 m=1
M00026 (N00026 N00022 inh_lSup inh_lSup) sky130_fd_pr__nfet_g5v0d10v5 w=0.625 l=0.5 nf=1 mult=1 ad=0.18125 as=0.18125 pd=1.83 ps=1.83 sa=0 sb=0 sd=0 m=1
D00027 (inh_lSup inh_hsupanalog) sky130_fd_pr__diode_pd2nw_05v5 area=1 perim=4 mult=1 m=1
M00028 (N00021 N00017 inh_hsupanalog inh_bulkpanalog) sky130_fd_pr__pfet_g5v0d10v5 w=2.875 l=0.5 nf=1 mult=1 ad=0.83375 as=0.83375 pd=6.33 ps=6.33 sa=0 sb=0 sd=0 m=1
M00029 (N00021 N00017 inh_lSup inh_lSup) sky130_fd_pr__nfet_g5v0d10v5 w=0.625 l=0.5 nf=1 mult=1 ad=0.18125 as=0.18125 pd=1.83 ps=1.83 sa=0 sb=0 sd=0 m=1
D00030 (inh_lSup inh_hsupanalog) sky130_fd_pr__diode_pd2nw_05v5 area=1 perim=4 mult=1 m=1
M00031 (N00024 N00022 inh_hsupanalog inh_bulkpanalog) sky130_fd_pr__pfet_g5v0d10v5 w=2.3 l=1 nf=1 mult=1 ad=0.667 as=0.667 pd=5.18 ps=5.18 sa=0 sb=0 sd=0 m=1
M00032 (N00024 N00022 inh_lSup inh_lSup) sky130_fd_pr__nfet_g5v0d10v5 w=0.5 l=1 nf=1 mult=1 ad=0.145 as=0.145 pd=1.58 ps=1.58 sa=0 sb=0 sd=0 m=1
D00033 (inh_lSup inh_hsupanalog) sky130_fd_pr__diode_pd2nw_05v5 area=1 perim=4 mult=1 m=1
M00034 (N00025 N00026 inh_hsupanalog inh_bulkpanalog) sky130_fd_pr__pfet_g5v0d10v5 w=2.3 l=1 nf=1 mult=1 ad=0.667 as=0.667 pd=5.18 ps=5.18 sa=0 sb=0 sd=0 m=1
M00035 (N00025 N00026 inh_lSup inh_lSup) sky130_fd_pr__nfet_g5v0d10v5 w=0.5 l=1 nf=1 mult=1 ad=0.145 as=0.145 pd=1.58 ps=1.58 sa=0 sb=0 sd=0 m=1
D00036 (inh_lSup inh_hsupanalog) sky130_fd_pr__diode_pd2nw_05v5 area=1 perim=4 mult=1 m=1
M00037 (N00022 N00024 inh_hsupanalog inh_bulkpanalog) sky130_fd_pr__pfet_g5v0d10v5 w=2.3 l=1 nf=1 mult=1 ad=0.667 as=0.667 pd=5.18 ps=5.18 sa=0 sb=0 sd=0 m=1
M00038 (N00022 N00024 inh_lSup inh_lSup) sky130_fd_pr__nfet_g5v0d10v5 w=0.5 l=1 nf=1 mult=1 ad=0.145 as=0.145 pd=1.58 ps=1.58 sa=0 sb=0 sd=0 m=1
D00039 (inh_lSup inh_hsupanalog) sky130_fd_pr__diode_pd2nw_05v5 area=1 perim=4 mult=1 m=1
M00040 (N00026 N00025 inh_hsupanalog inh_bulkpanalog) sky130_fd_pr__pfet_g5v0d10v5 w=2.3 l=1 nf=1 mult=1 ad=0.667 as=0.667 pd=5.18 ps=5.18 sa=0 sb=0 sd=0 m=1
M00041 (N00026 N00025 inh_lSup inh_lSup) sky130_fd_pr__nfet_g5v0d10v5 w=0.5 l=1 nf=1 mult=1 ad=0.145 as=0.145 pd=1.58 ps=1.58 sa=0 sb=0 sd=0 m=1
D00042 (inh_lSup inh_hsupanalog) sky130_fd_pr__diode_pd2nw_05v5 area=1 perim=4 mult=1 m=1
M00043 (N00027 inh_lSup N00028 inh_bulkpanalog) sky130_fd_pr__pfet_g5v0d10v5 w=2.875 l=0.5 nf=1 mult=1 ad=0.83375 as=0.83375 pd=6.33 ps=6.33 sa=0 sb=0 sd=0 m=1
M00044 (N00027 inh_hsupanalog N00028 inh_lSup) sky130_fd_pr__nfet_g5v0d10v5 w=0.625 l=0.5 nf=1 mult=1 ad=0.18125 as=0.18125 pd=1.83 ps=1.83 sa=0 sb=0 sd=0 m=1
M00045 (N00029 N00012 inh_hsupanalog inh_bulkpanalog) sky130_fd_pr__pfet_g5v0d10v5 w=2.875 l=0.5 nf=1 mult=1 ad=0.83375 as=0.83375 pd=6.33 ps=6.33 sa=0 sb=0 sd=0 m=1
M00046 (N00029 N00012 inh_lSup inh_lSup) sky130_fd_pr__nfet_g5v0d10v5 w=0.625 l=0.5 nf=1 mult=1 ad=0.18125 as=0.18125 pd=1.83 ps=1.83 sa=0 sb=0 sd=0 m=1
D00047 (inh_lSup inh_hsupanalog) sky130_fd_pr__diode_pd2nw_05v5 area=1 perim=4 mult=1 m=1
M00048 (N00030 N00029 inh_hsupanalog inh_bulkpanalog) sky130_fd_pr__pfet_g5v0d10v5 w=2.875 l=0.5 nf=1 mult=1 ad=0.83375 as=0.83375 pd=6.33 ps=6.33 sa=0 sb=0 sd=0 m=1
M00049 (N00030 N00029 inh_lSup inh_lSup) sky130_fd_pr__nfet_g5v0d10v5 w=0.625 l=0.5 nf=1 mult=1 ad=0.18125 as=0.18125 pd=1.83 ps=1.83 sa=0 sb=0 sd=0 m=1
D00050 (inh_lSup inh_hsupanalog) sky130_fd_pr__diode_pd2nw_05v5 area=1 perim=4 mult=1 m=1
M00051 (N00031 N00030 inh_hsupanalog inh_bulkpanalog) sky130_fd_pr__pfet_g5v0d10v5 w=2.875 l=0.5 nf=1 mult=1 ad=0.83375 as=0.83375 pd=6.33 ps=6.33 sa=0 sb=0 sd=0 m=1
M00052 (N00031 N00030 inh_lSup inh_lSup) sky130_fd_pr__nfet_g5v0d10v5 w=0.625 l=0.5 nf=1 mult=1 ad=0.18125 as=0.18125 pd=1.83 ps=1.83 sa=0 sb=0 sd=0 m=1
D00053 (inh_lSup inh_hsupanalog) sky130_fd_pr__diode_pd2nw_05v5 area=1 perim=4 mult=1 m=1
M00054 (N00032 N00028 inh_hsupanalog inh_bulkpanalog) sky130_fd_pr__pfet_g5v0d10v5 w=2.875 l=0.5 nf=1 mult=1 ad=0.83375 as=0.83375 pd=6.33 ps=6.33 sa=0 sb=0 sd=0 m=1
M00055 (N00032 N00028 inh_lSup inh_lSup) sky130_fd_pr__nfet_g5v0d10v5 w=0.625 l=0.5 nf=1 mult=1 ad=0.18125 as=0.18125 pd=1.83 ps=1.83 sa=0 sb=0 sd=0 m=1
D00056 (inh_lSup inh_hsupanalog) sky130_fd_pr__diode_pd2nw_05v5 area=1 perim=4 mult=1 m=1
M00057 (N00027 N00012 inh_hsupanalog inh_bulkpanalog) sky130_fd_pr__pfet_g5v0d10v5 w=2.875 l=0.5 nf=1 mult=1 ad=0.83375 as=0.83375 pd=6.33 ps=6.33 sa=0 sb=0 sd=0 m=1
M00058 (N00027 N00012 inh_lSup inh_lSup) sky130_fd_pr__nfet_g5v0d10v5 w=0.625 l=0.5 nf=1 mult=1 ad=0.18125 as=0.18125 pd=1.83 ps=1.83 sa=0 sb=0 sd=0 m=1
D00059 (inh_lSup inh_hsupanalog) sky130_fd_pr__diode_pd2nw_05v5 area=1 perim=4 mult=1 m=1
M00060 (N00030 N00028 inh_hsupanalog inh_bulkpanalog) sky130_fd_pr__pfet_g5v0d10v5 w=2.3 l=1 nf=1 mult=1 ad=0.667 as=0.667 pd=5.18 ps=5.18 sa=0 sb=0 sd=0 m=1
M00061 (N00030 N00028 inh_lSup inh_lSup) sky130_fd_pr__nfet_g5v0d10v5 w=0.5 l=1 nf=1 mult=1 ad=0.145 as=0.145 pd=1.58 ps=1.58 sa=0 sb=0 sd=0 m=1
D00062 (inh_lSup inh_hsupanalog) sky130_fd_pr__diode_pd2nw_05v5 area=1 perim=4 mult=1 m=1
M00063 (N00031 N00032 inh_hsupanalog inh_bulkpanalog) sky130_fd_pr__pfet_g5v0d10v5 w=2.3 l=1 nf=1 mult=1 ad=0.667 as=0.667 pd=5.18 ps=5.18 sa=0 sb=0 sd=0 m=1
M00064 (N00031 N00032 inh_lSup inh_lSup) sky130_fd_pr__nfet_g5v0d10v5 w=0.5 l=1 nf=1 mult=1 ad=0.145 as=0.145 pd=1.58 ps=1.58 sa=0 sb=0 sd=0 m=1
D00065 (inh_lSup inh_hsupanalog) sky130_fd_pr__diode_pd2nw_05v5 area=1 perim=4 mult=1 m=1
M00066 (N00028 N00030 inh_hsupanalog inh_bulkpanalog) sky130_fd_pr__pfet_g5v0d10v5 w=2.3 l=1 nf=1 mult=1 ad=0.667 as=0.667 pd=5.18 ps=5.18 sa=0 sb=0 sd=0 m=1
M00067 (N00028 N00030 inh_lSup inh_lSup) sky130_fd_pr__nfet_g5v0d10v5 w=0.5 l=1 nf=1 mult=1 ad=0.145 as=0.145 pd=1.58 ps=1.58 sa=0 sb=0 sd=0 m=1
D00068 (inh_lSup inh_hsupanalog) sky130_fd_pr__diode_pd2nw_05v5 area=1 perim=4 mult=1 m=1
M00069 (N00032 N00031 inh_hsupanalog inh_bulkpanalog) sky130_fd_pr__pfet_g5v0d10v5 w=2.3 l=1 nf=1 mult=1 ad=0.667 as=0.667 pd=5.18 ps=5.18 sa=0 sb=0 sd=0 m=1
M00070 (N00032 N00031 inh_lSup inh_lSup) sky130_fd_pr__nfet_g5v0d10v5 w=0.5 l=1 nf=1 mult=1 ad=0.145 as=0.145 pd=1.58 ps=1.58 sa=0 sb=0 sd=0 m=1
D00071 (inh_lSup inh_hsupanalog) sky130_fd_pr__diode_pd2nw_05v5 area=1 perim=4 mult=1 m=1
M00072 (N00033 N00034 inh_lSup inh_bulkn) sky130_fd_pr__nfet_g5v0d10v5 w=1 l=1 nf=1 mult=1 ad=0.29 as=0.29 pd=2.58 ps=2.58 sa=0 sb=0 sd=0 m=1
M00073 (N00034 N00035 inh_lSup inh_bulkn) sky130_fd_pr__nfet_g5v0d10v5 w=2 l=1 nf=1 mult=1 ad=0.58 as=0.58 pd=4.58 ps=4.58 sa=0 sb=0 sd=0 m=1
M00074 (N00035 N00034 inh_lSup inh_bulkn) sky130_fd_pr__nfet_g5v0d10v5 w=2 l=1 nf=1 mult=1 ad=0.58 as=0.58 pd=4.58 ps=4.58 sa=0 sb=0 sd=0 m=1
M00075 (N00036 N00035 inh_lSup inh_bulkn) sky130_fd_pr__nfet_g5v0d10v5 w=1 l=1 nf=1 mult=1 ad=0.29 as=0.29 pd=2.58 ps=2.58 sa=0 sb=0 sd=0 m=1
M00076 (N00034 N00034 inh_lSup inh_bulkn) sky130_fd_pr__nfet_g5v0d10v5 w=1 l=1 nf=1 mult=1 ad=0.29 as=0.29 pd=2.58 ps=2.58 sa=0 sb=0 sd=0 m=1
M00077 (N00035 N00035 inh_lSup inh_bulkn) sky130_fd_pr__nfet_g5v0d10v5 w=1 l=1 nf=1 mult=1 ad=0.29 as=0.29 pd=2.58 ps=2.58 sa=0 sb=0 sd=0 m=1
M00078 (N00037 N00038 N00039 inh_bulkn) sky130_fd_pr__nfet_g5v0d10v5 w=12.5 l=0.5 nf=1 mult=4 ad=3.625 as=3.625 pd=25.58 ps=25.58 sa=0 sb=0 sd=0 m=4
M00079 (N00040 vref_ai N00039 inh_bulkn) sky130_fd_pr__nfet_g5v0d10v5 w=12.5 l=0.5 nf=1 mult=4 ad=3.625 as=3.625 pd=25.58 ps=25.58 sa=0 sb=0 sd=0 m=4
M00080 (N00036 N00036 inh_hsupanalog inh_bulkpanalog) sky130_fd_pr__pfet_g5v0d10v5 w=1 l=1 nf=1 mult=1 ad=0.29 as=0.29 pd=2.58 ps=2.58 sa=0 sb=0 sd=0 m=1
M00081 (N00033 N00036 inh_hsupanalog inh_bulkpanalog) sky130_fd_pr__pfet_g5v0d10v5 w=1 l=1 nf=1 mult=1 ad=0.29 as=0.29 pd=2.58 ps=2.58 sa=0 sb=0 sd=0 m=1
M00082 (N00040 N00040 inh_hsupanalog inh_bulkpanalog) sky130_fd_pr__pfet_g5v0d10v5 w=1 l=1 nf=1 mult=1 ad=0.29 as=0.29 pd=2.58 ps=2.58 sa=0 sb=0 sd=0 m=1
M00083 (N00037 N00037 inh_hsupanalog inh_bulkpanalog) sky130_fd_pr__pfet_g5v0d10v5 w=1 l=1 nf=1 mult=1 ad=0.29 as=0.29 pd=2.58 ps=2.58 sa=0 sb=0 sd=0 m=1
M00084 (N00034 N00037 inh_hsupanalog inh_bulkpanalog) sky130_fd_pr__pfet_g5v0d10v5 w=1 l=1 nf=1 mult=2 ad=0.29 as=0.29 pd=2.58 ps=2.58 sa=0 sb=0 sd=0 m=2
M00085 (N00035 N00040 inh_hsupanalog inh_bulkpanalog) sky130_fd_pr__pfet_g5v0d10v5 w=1 l=1 nf=1 mult=2 ad=0.29 as=0.29 pd=2.58 ps=2.58 sa=0 sb=0 sd=0 m=2
R00086 (N00039 inh_lSup) resistor r=1MEG
M00087 (N00041 N00033 inh_hsupanalog inh_bulkpanalog) sky130_fd_pr__pfet_g5v0d10v5 w=2.875 l=0.5 nf=1 mult=1 ad=0.83375 as=0.83375 pd=6.33 ps=6.33 sa=0 sb=0 sd=0 m=1
M00088 (N00041 N00033 inh_lSup inh_bulkn) sky130_fd_pr__nfet_g5v0d10v5 w=0.625 l=0.5 nf=1 mult=1 ad=0.18125 as=0.18125 pd=1.83 ps=1.83 sa=0 sb=0 sd=0 m=1
D00089 (inh_lSup inh_hsupanalog) sky130_fd_pr__diode_pd2nw_05v5 area=1 perim=4 mult=1 m=1
M00090 (N00042 N00043 inh_lSup inh_bulkn) sky130_fd_pr__nfet_g5v0d10v5 w=1 l=1 nf=1 mult=1 ad=0.29 as=0.29 pd=2.58 ps=2.58 sa=0 sb=0 sd=0 m=1
M00091 (N00043 N00044 inh_lSup inh_bulkn) sky130_fd_pr__nfet_g5v0d10v5 w=2 l=1 nf=1 mult=1 ad=0.58 as=0.58 pd=4.58 ps=4.58 sa=0 sb=0 sd=0 m=1
M00092 (N00044 N00043 inh_lSup inh_bulkn) sky130_fd_pr__nfet_g5v0d10v5 w=2 l=1 nf=1 mult=1 ad=0.58 as=0.58 pd=4.58 ps=4.58 sa=0 sb=0 sd=0 m=1
M00093 (N00045 N00044 inh_lSup inh_bulkn) sky130_fd_pr__nfet_g5v0d10v5 w=1 l=1 nf=1 mult=1 ad=0.29 as=0.29 pd=2.58 ps=2.58 sa=0 sb=0 sd=0 m=1
M00094 (N00043 N00043 inh_lSup inh_bulkn) sky130_fd_pr__nfet_g5v0d10v5 w=1 l=1 nf=1 mult=1 ad=0.29 as=0.29 pd=2.58 ps=2.58 sa=0 sb=0 sd=0 m=1
M00095 (N00044 N00044 inh_lSup inh_bulkn) sky130_fd_pr__nfet_g5v0d10v5 w=1 l=1 nf=1 mult=1 ad=0.29 as=0.29 pd=2.58 ps=2.58 sa=0 sb=0 sd=0 m=1
M00096 (N00046 vref_ai N00047 inh_bulkn) sky130_fd_pr__nfet_g5v0d10v5 w=12.5 l=0.5 nf=1 mult=4 ad=3.625 as=3.625 pd=25.58 ps=25.58 sa=0 sb=0 sd=0 m=4
M00097 (N00048 N00049 N00047 inh_bulkn) sky130_fd_pr__nfet_g5v0d10v5 w=12.5 l=0.5 nf=1 mult=4 ad=3.625 as=3.625 pd=25.58 ps=25.58 sa=0 sb=0 sd=0 m=4
M00098 (N00045 N00045 inh_hsupanalog inh_bulkpanalog) sky130_fd_pr__pfet_g5v0d10v5 w=1 l=1 nf=1 mult=1 ad=0.29 as=0.29 pd=2.58 ps=2.58 sa=0 sb=0 sd=0 m=1
M00099 (N00042 N00045 inh_hsupanalog inh_bulkpanalog) sky130_fd_pr__pfet_g5v0d10v5 w=1 l=1 nf=1 mult=1 ad=0.29 as=0.29 pd=2.58 ps=2.58 sa=0 sb=0 sd=0 m=1
M00100 (N00048 N00048 inh_hsupanalog inh_bulkpanalog) sky130_fd_pr__pfet_g5v0d10v5 w=1 l=1 nf=1 mult=1 ad=0.29 as=0.29 pd=2.58 ps=2.58 sa=0 sb=0 sd=0 m=1
M00101 (N00046 N00046 inh_hsupanalog inh_bulkpanalog) sky130_fd_pr__pfet_g5v0d10v5 w=1 l=1 nf=1 mult=1 ad=0.29 as=0.29 pd=2.58 ps=2.58 sa=0 sb=0 sd=0 m=1
M00102 (N00043 N00046 inh_hsupanalog inh_bulkpanalog) sky130_fd_pr__pfet_g5v0d10v5 w=1 l=1 nf=1 mult=2 ad=0.29 as=0.29 pd=2.58 ps=2.58 sa=0 sb=0 sd=0 m=2
M00103 (N00044 N00048 inh_hsupanalog inh_bulkpanalog) sky130_fd_pr__pfet_g5v0d10v5 w=1 l=1 nf=1 mult=2 ad=0.29 as=0.29 pd=2.58 ps=2.58 sa=0 sb=0 sd=0 m=2
R00104 (N00047 inh_lSup) resistor r=1MEG
M00105 (N00050 N00042 inh_hsupanalog inh_bulkpanalog) sky130_fd_pr__pfet_g5v0d10v5 w=2.875 l=0.5 nf=1 mult=1 ad=0.83375 as=0.83375 pd=6.33 ps=6.33 sa=0 sb=0 sd=0 m=1
M00106 (N00050 N00042 inh_lSup inh_bulkn) sky130_fd_pr__nfet_g5v0d10v5 w=0.625 l=0.5 nf=1 mult=1 ad=0.18125 as=0.18125 pd=1.83 ps=1.83 sa=0 sb=0 sd=0 m=1
D00107 (inh_lSup inh_hsupanalog) sky130_fd_pr__diode_pd2nw_05v5 area=1 perim=4 mult=1 m=1
M00108 (N00051 overvoltage_o inh_lSup inh_lSup) sky130_fd_pr__nfet_g5v0d10v5 w=1.125 l=0.5 nf=1 mult=1 ad=0.32625 as=0.32625 pd=2.83 ps=2.83 sa=0 sb=0 sd=0 m=1
M00109 (N00051 undervoltage_o inh_lSup inh_lSup) sky130_fd_pr__nfet_g5v0d10v5 w=1.125 l=0.5 nf=1 mult=1 ad=0.32625 as=0.32625 pd=2.83 ps=2.83 sa=0 sb=0 sd=0 m=1
M00110 (N00052 N00051 inh_lSup inh_lSup) sky130_fd_pr__nfet_g5v0d10v5 w=0.75 l=0.5 nf=1 mult=1 ad=0.2175 as=0.2175 pd=2.08 ps=2.08 sa=0 sb=0 sd=0 m=1
M00111 (N00051 overvoltage_o N00053 inh_bulkpanalog) sky130_fd_pr__pfet_g5v0d10v5 w=1.6 l=0.5 nf=1 mult=1 ad=0.464 as=0.464 pd=3.78 ps=3.78 sa=0 sb=0 sd=0 m=1
M00112 (N00053 undervoltage_o inh_hsupanalog inh_bulkpanalog) sky130_fd_pr__pfet_g5v0d10v5 w=1.6 l=0.5 nf=1 mult=1 ad=0.464 as=0.464 pd=3.78 ps=3.78 sa=0 sb=0 sd=0 m=1
M00113 (N00052 N00051 inh_hsupanalog inh_bulkpanalog) sky130_fd_pr__pfet_g5v0d10v5 w=1.075 l=0.5 nf=1 mult=1 ad=0.31175 as=0.31175 pd=2.73 ps=2.73 sa=0 sb=0 sd=0 m=1
D00114 (inh_lSup inh_hsupanalog) sky130_fd_pr__diode_pd2nw_05v5 area=1 perim=4 mult=1 m=1
M00115 (N00054 disable_i inh_lSup inh_lSup) sky130_fd_pr__nfet_g5v0d10v5 w=1.125 l=0.5 nf=1 mult=1 ad=0.32625 as=0.32625 pd=2.83 ps=2.83 sa=0 sb=0 sd=0 m=1
M00116 (N00054 N00052 inh_lSup inh_lSup) sky130_fd_pr__nfet_g5v0d10v5 w=1.125 l=0.5 nf=1 mult=1 ad=0.32625 as=0.32625 pd=2.83 ps=2.83 sa=0 sb=0 sd=0 m=1
M00117 (N00055 N00054 inh_lSup inh_lSup) sky130_fd_pr__nfet_g5v0d10v5 w=0.75 l=0.5 nf=1 mult=1 ad=0.2175 as=0.2175 pd=2.08 ps=2.08 sa=0 sb=0 sd=0 m=1
M00118 (N00054 disable_i N00056 inh_bulkpanalog) sky130_fd_pr__pfet_g5v0d10v5 w=1.6 l=0.5 nf=1 mult=1 ad=0.464 as=0.464 pd=3.78 ps=3.78 sa=0 sb=0 sd=0 m=1
M00119 (N00056 N00052 inh_hsupanalog inh_bulkpanalog) sky130_fd_pr__pfet_g5v0d10v5 w=1.6 l=0.5 nf=1 mult=1 ad=0.464 as=0.464 pd=3.78 ps=3.78 sa=0 sb=0 sd=0 m=1
M00120 (N00055 N00054 inh_hsupanalog inh_bulkpanalog) sky130_fd_pr__pfet_g5v0d10v5 w=1.075 l=0.5 nf=1 mult=1 ad=0.31175 as=0.31175 pd=2.73 ps=2.73 sa=0 sb=0 sd=0 m=1
D00121 (inh_lSup inh_hsupanalog) sky130_fd_pr__diode_pd2nw_05v5 area=1 perim=4 mult=1 m=1
M00122 (N00057 N00058 inh_hsupanalog inh_bulkpanalog) sky130_fd_pr__pfet_g5v0d10v5 w=4.3 l=0.5 nf=1 mult=1 ad=1.247 as=1.247 pd=9.18 ps=9.18 sa=0 sb=0 sd=0 m=1
M00123 (N00059 N00057 inh_hsupanalog inh_bulkpanalog) sky130_fd_pr__pfet_g5v0d10v5 w=6.44 l=0.5 nf=1 mult=1 ad=1.8676 as=1.8676 pd=13.46 ps=13.46 sa=0 sb=0 sd=0 m=1
M00124 (N00057 N00058 inh_lSup inh_lSup) sky130_fd_pr__nfet_g5v0d10v5 w=1.025 l=0.5 nf=1 mult=1 ad=0.29725 as=0.29725 pd=2.63 ps=2.63 sa=0 sb=0 sd=0 m=1
M00125 (N00059 N00057 inh_lSup inh_lSup) sky130_fd_pr__nfet_g5v0d10v5 w=1.4 l=0.5 nf=1 mult=1 ad=0.406 as=0.406 pd=3.38 ps=3.38 sa=0 sb=0 sd=0 m=1
D00126 (inh_lSup inh_hsupanalog) sky130_fd_pr__diode_pd2nw_05v5 area=1 perim=4 mult=1 m=1
M00127 (undervoltage_o N00041 inh_hsupanalog inh_bulkpanalog) sky130_fd_pr__pfet_g5v0d10v5 w=2.875 l=0.5 nf=1 mult=1 ad=0.83375 as=0.83375 pd=6.33 ps=6.33 sa=0 sb=0 sd=0 m=1
M00128 (undervoltage_o N00041 inh_lSup inh_lSup) sky130_fd_pr__nfet_g5v0d10v5 w=0.625 l=0.5 nf=1 mult=1 ad=0.18125 as=0.18125 pd=1.83 ps=1.83 sa=0 sb=0 sd=0 m=1
D00129 (inh_lSup inh_hsupanalog) sky130_fd_pr__diode_pd2nw_05v5 area=1 perim=4 mult=1 m=1
M00130 (overvoltage_o N00050 inh_hsupanalog inh_bulkpanalog) sky130_fd_pr__pfet_g5v0d10v5 w=2.875 l=0.5 nf=1 mult=1 ad=0.83375 as=0.83375 pd=6.33 ps=6.33 sa=0 sb=0 sd=0 m=1
M00131 (overvoltage_o N00050 inh_lSup inh_lSup) sky130_fd_pr__nfet_g5v0d10v5 w=0.625 l=0.5 nf=1 mult=1 ad=0.18125 as=0.18125 pd=1.83 ps=1.83 sa=0 sb=0 sd=0 m=1
D00132 (inh_lSup inh_hsupanalog) sky130_fd_pr__diode_pd2nw_05v5 area=1 perim=4 mult=1 m=1
M00133 (N00015 N00055 inh_hsupanalog inh_bulkpanalog) sky130_fd_pr__pfet_g5v0d10v5 w=2.875 l=0.5 nf=1 mult=1 ad=0.83375 as=0.83375 pd=6.33 ps=6.33 sa=0 sb=0 sd=0 m=1
M00134 (N00015 N00055 inh_lSup inh_lSup) sky130_fd_pr__nfet_g5v0d10v5 w=0.625 l=0.5 nf=1 mult=1 ad=0.18125 as=0.18125 pd=1.83 ps=1.83 sa=0 sb=0 sd=0 m=1
D00135 (inh_lSup inh_hsupanalog) sky130_fd_pr__diode_pd2nw_05v5 area=1 perim=4 mult=1 m=1
M00136 (N00058 clk_i inh_hsupanalog inh_bulkpanalog) sky130_fd_pr__pfet_g5v0d10v5 w=1.075 l=0.5 nf=1 mult=1 ad=0.31175 as=0.31175 pd=2.73 ps=2.73 sa=0 sb=0 sd=0 m=1
M00137 (N00058 N00015 inh_hsupanalog inh_bulkpanalog) sky130_fd_pr__pfet_g5v0d10v5 w=1.075 l=0.5 nf=1 mult=1 ad=0.31175 as=0.31175 pd=2.73 ps=2.73 sa=0 sb=0 sd=0 m=1
M00138 (N00060 clk_i inh_lSup inh_lSup) sky130_fd_pr__nfet_g5v0d10v5 w=1.075 l=0.5 nf=1 mult=1 ad=0.31175 as=0.31175 pd=2.73 ps=2.73 sa=0 sb=0 sd=0 m=1
M00139 (N00058 N00015 N00060 inh_lSup) sky130_fd_pr__nfet_g5v0d10v5 w=1.075 l=0.5 nf=1 mult=1 ad=0.31175 as=0.31175 pd=2.73 ps=2.73 sa=0 sb=0 sd=0 m=1
D00140 (inh_lSup inh_hsupanalog) sky130_fd_pr__diode_pd2nw_05v5 area=1 perim=4 mult=1 m=1
C00141 (N00061 inh_lSup) capacitor c=500f
C00142 (N00062 inh_lSup) capacitor c=500f
M00143 (N00062 N00032 N00063 inh_bulkn) sky130_fd_pr__nfet_g5v0d10v5 w=0.5 l=0.5 nf=1 mult=1 ad=0.145 as=0.145 pd=1.58 ps=1.58 sa=0 sb=0 sd=0 m=1
M00144 (N00063 N00031 N00062 inh_bulkpanalog) sky130_fd_pr__pfet_g5v0d10v5 w=0.5 l=0.5 nf=1 mult=1 ad=0.145 as=0.145 pd=1.58 ps=1.58 sa=0 sb=0 sd=0 m=1
M00145 (N00064 N00026 N00062 inh_bulkn) sky130_fd_pr__nfet_g5v0d10v5 w=0.5 l=0.5 nf=1 mult=1 ad=0.145 as=0.145 pd=1.58 ps=1.58 sa=0 sb=0 sd=0 m=1
M00146 (N00062 N00025 N00064 inh_bulkpanalog) sky130_fd_pr__pfet_g5v0d10v5 w=0.5 l=0.5 nf=1 mult=1 ad=0.145 as=0.145 pd=1.58 ps=1.58 sa=0 sb=0 sd=0 m=1
M00147 (N00061 N00026 N00063 inh_bulkn) sky130_fd_pr__nfet_g5v0d10v5 w=0.5 l=0.5 nf=1 mult=1 ad=0.145 as=0.145 pd=1.58 ps=1.58 sa=0 sb=0 sd=0 m=1
M00148 (N00063 N00025 N00061 inh_bulkpanalog) sky130_fd_pr__pfet_g5v0d10v5 w=0.5 l=0.5 nf=1 mult=1 ad=0.145 as=0.145 pd=1.58 ps=1.58 sa=0 sb=0 sd=0 m=1
M00149 (N00064 N00032 N00061 inh_bulkn) sky130_fd_pr__nfet_g5v0d10v5 w=0.5 l=0.5 nf=1 mult=1 ad=0.145 as=0.145 pd=1.58 ps=1.58 sa=0 sb=0 sd=0 m=1
M00150 (N00061 N00031 N00064 inh_bulkpanalog) sky130_fd_pr__pfet_g5v0d10v5 w=0.5 l=0.5 nf=1 mult=1 ad=0.145 as=0.145 pd=1.58 ps=1.58 sa=0 sb=0 sd=0 m=1
M00151 (N00062 N00065 inh_hsupanalog inh_bulkpanalog) sky130_fd_pr__pfet_g5v0d10v5 w=0.5 l=0.5 nf=1 mult=1 ad=0.145 as=0.145 pd=1.58 ps=1.58 sa=0 sb=0 sd=0 m=1
M00152 (N00061 N00065 inh_hsupanalog inh_bulkpanalog) sky130_fd_pr__pfet_g5v0d10v5 w=0.5 l=0.5 nf=1 mult=1 ad=0.145 as=0.145 pd=1.58 ps=1.58 sa=0 sb=0 sd=0 m=1
M00153 (N00065 N00055 inh_hsupanalog inh_bulkpanalog) sky130_fd_pr__pfet_g5v0d10v5 w=6.44 l=0.5 nf=1 mult=1 ad=1.8676 as=1.8676 pd=13.46 ps=13.46 sa=0 sb=0 sd=0 m=1
M00154 (N00065 N00055 inh_lSup inh_bulkn) sky130_fd_pr__nfet_g5v0d10v5 w=1.4 l=0.5 nf=1 mult=1 ad=0.406 as=0.406 pd=3.38 ps=3.38 sa=0 sb=0 sd=0 m=1
D00155 (inh_lSup inh_hsupanalog) sky130_fd_pr__diode_pd2nw_05v5 area=1 perim=4 mult=1 m=1
M00156 (N00066 N00058 inh_hsupanalog inh_bulkpanalog) sky130_fd_pr__pfet_g5v0d10v5 w=6.44 l=0.5 nf=1 mult=1 ad=1.8676 as=1.8676 pd=13.46 ps=13.46 sa=0 sb=0 sd=0 m=1
M00157 (N00066 N00058 inh_lSup inh_lSup) sky130_fd_pr__nfet_g5v0d10v5 w=1.4 l=0.5 nf=1 mult=1 ad=0.406 as=0.406 pd=3.38 ps=3.38 sa=0 sb=0 sd=0 m=1
D00158 (inh_lSup inh_hsupanalog) sky130_fd_pr__diode_pd2nw_05v5 area=1 perim=4 mult=1 m=1
R00159 (vout_1V5_ao N00067) resistor r=300K
R00160 (N00067 inh_lSup) resistor r=1.2MEG
M00161 (N00068 N00055 inh_hsupanalog inh_bulkpanalog) sky130_fd_pr__pfet_g5v0d10v5 w=2.875 l=0.5 nf=1 mult=1 ad=0.83375 as=0.83375 pd=6.33 ps=6.33 sa=0 sb=0 sd=0 m=1
M00162 (N00068 N00055 inh_lSup inh_lSup) sky130_fd_pr__nfet_g5v0d10v5 w=0.625 l=0.5 nf=1 mult=1 ad=0.18125 as=0.18125 pd=1.83 ps=1.83 sa=0 sb=0 sd=0 m=1
D00163 (inh_lSup inh_hsupanalog) sky130_fd_pr__diode_pd2nw_05v5 area=1 perim=4 mult=1 m=1
M00164 (N00069 N00055 inh_hsupanalog inh_bulkpanalog) sky130_fd_pr__pfet_g5v0d10v5 w=0.42 l=20 nf=1 mult=1 ad=0.1218 as=0.1218 pd=1.42 ps=1.42 sa=0 sb=0 sd=0 m=1
M00165 (N00069 N00068 inh_hsupanalog inh_bulkpanalog) sky130_fd_pr__pfet_g5v0d10v5 w=0.5 l=0.5 nf=1 mult=1 ad=0.145 as=0.145 pd=1.58 ps=1.58 sa=0 sb=0 sd=0 m=1
M00166 (N00063 N00055 inh_lSup inh_bulkn) sky130_fd_pr__nfet_g5v0d10v5 w=0.5 l=0.5 nf=1 mult=1 ad=0.145 as=0.145 pd=1.58 ps=1.58 sa=0 sb=0 sd=0 m=1
M00167 (vout_1V5_ao N00069 inh_hsupanalog inh_bulkpanalog) sky130_fd_pr__pfet_g5v0d10v5 w=50 l=0.5 nf=1 mult=150 ad=14.5 as=14.5 pd=100.58 ps=100.58 sa=0 sb=0 sd=0 m=150
M00168 (N00069 N00063 vout_1V5_ao inh_bulkn) sky130_fd_pr__nfet_g5v0d10v5 w=12.5 l=0.5 nf=1 mult=2 ad=3.625 as=3.625 pd=25.58 ps=25.58 sa=0 sb=0 sd=0 m=2
M00169 (N00069 N00063 vout_1V5_ao inh_bulkn) sky130_fd_pr__nfet_g5v0d10v5 w=12.5 l=0.5 nf=1 mult=2 ad=3.625 as=3.625 pd=25.58 ps=25.58 sa=0 sb=0 sd=0 m=2
M00170 (N00069 N00063 vout_1V5_ao inh_bulkn) sky130_fd_pr__nfet_g5v0d10v5 w=12.5 l=0.5 nf=1 mult=2 ad=3.625 as=3.625 pd=25.58 ps=25.58 sa=0 sb=0 sd=0 m=2
M00171 (N00069 N00063 vout_1V5_ao inh_bulkn) sky130_fd_pr__nfet_g5v0d10v5 w=12.5 l=0.5 nf=1 mult=2 ad=3.625 as=3.625 pd=25.58 ps=25.58 sa=0 sb=0 sd=0 m=2
M00172 (N00069 N00063 vout_1V5_ao inh_bulkn) sky130_fd_pr__nfet_g5v0d10v5 w=12.5 l=0.5 nf=1 mult=2 ad=3.625 as=3.625 pd=25.58 ps=25.58 sa=0 sb=0 sd=0 m=2
M00173 (N00069 N00063 vout_1V5_ao inh_bulkn) sky130_fd_pr__nfet_g5v0d10v5 w=12.5 l=0.5 nf=1 mult=2 ad=3.625 as=3.625 pd=25.58 ps=25.58 sa=0 sb=0 sd=0 m=2
M00174 (N00069 N00063 vout_1V5_ao inh_bulkn) sky130_fd_pr__nfet_g5v0d10v5 w=12.5 l=0.5 nf=1 mult=2 ad=3.625 as=3.625 pd=25.58 ps=25.58 sa=0 sb=0 sd=0 m=2
M00175 (N00069 N00063 vout_1V5_ao inh_bulkn) sky130_fd_pr__nfet_g5v0d10v5 w=12.5 l=0.5 nf=1 mult=2 ad=3.625 as=3.625 pd=25.58 ps=25.58 sa=0 sb=0 sd=0 m=2
M00176 (N00069 N00063 vout_1V5_ao inh_bulkn) sky130_fd_pr__nfet_g5v0d10v5 w=12.5 l=0.5 nf=1 mult=2 ad=3.625 as=3.625 pd=25.58 ps=25.58 sa=0 sb=0 sd=0 m=2
M00177 (N00069 N00063 vout_1V5_ao inh_bulkn) sky130_fd_pr__nfet_g5v0d10v5 w=12.5 l=0.5 nf=1 mult=2 ad=3.625 as=3.625 pd=25.58 ps=25.58 sa=0 sb=0 sd=0 m=2
M00178 (N00069 N00063 vout_1V5_ao inh_bulkn) sky130_fd_pr__nfet_g5v0d10v5 w=12.5 l=0.5 nf=1 mult=2 ad=3.625 as=3.625 pd=25.58 ps=25.58 sa=0 sb=0 sd=0 m=2
M00179 (N00069 N00063 vout_1V5_ao inh_bulkn) sky130_fd_pr__nfet_g5v0d10v5 w=12.5 l=0.5 nf=1 mult=2 ad=3.625 as=3.625 pd=25.58 ps=25.58 sa=0 sb=0 sd=0 m=2
M00180 (N00070 N00071 inh_hsupanalog inh_bulkpanalog) sky130_fd_pr__pfet_g5v0d10v5 w=1.075 l=0.5 nf=1 mult=1 ad=0.31175 as=0.31175 pd=2.73 ps=2.73 sa=0 sb=0 sd=0 m=1
M00181 (N00070 N00072 inh_hsupanalog inh_bulkpanalog) sky130_fd_pr__pfet_g5v0d10v5 w=1.075 l=0.5 nf=1 mult=1 ad=0.31175 as=0.31175 pd=2.73 ps=2.73 sa=0 sb=0 sd=0 m=1
M00182 (N00073 N00071 inh_lSup inh_lSup) sky130_fd_pr__nfet_g5v0d10v5 w=1.075 l=0.5 nf=1 mult=1 ad=0.31175 as=0.31175 pd=2.73 ps=2.73 sa=0 sb=0 sd=0 m=1
M00183 (N00070 N00072 N00073 inh_lSup) sky130_fd_pr__nfet_g5v0d10v5 w=1.075 l=0.5 nf=1 mult=1 ad=0.31175 as=0.31175 pd=2.73 ps=2.73 sa=0 sb=0 sd=0 m=1
D00184 (inh_lSup inh_hsupanalog) sky130_fd_pr__diode_pd2nw_05v5 area=1 perim=4 mult=1 m=1
M00185 (N00071 N00070 inh_hsupanalog inh_bulkpanalog) sky130_fd_pr__pfet_g5v0d10v5 w=1.075 l=0.5 nf=1 mult=1 ad=0.31175 as=0.31175 pd=2.73 ps=2.73 sa=0 sb=0 sd=0 m=1
M00186 (N00071 N00074 inh_hsupanalog inh_bulkpanalog) sky130_fd_pr__pfet_g5v0d10v5 w=1.075 l=0.5 nf=1 mult=1 ad=0.31175 as=0.31175 pd=2.73 ps=2.73 sa=0 sb=0 sd=0 m=1
M00187 (N00075 N00070 inh_lSup inh_lSup) sky130_fd_pr__nfet_g5v0d10v5 w=1.075 l=0.5 nf=1 mult=1 ad=0.31175 as=0.31175 pd=2.73 ps=2.73 sa=0 sb=0 sd=0 m=1
M00188 (N00071 N00074 N00075 inh_lSup) sky130_fd_pr__nfet_g5v0d10v5 w=1.075 l=0.5 nf=1 mult=1 ad=0.31175 as=0.31175 pd=2.73 ps=2.73 sa=0 sb=0 sd=0 m=1
D00189 (inh_lSup inh_hsupanalog) sky130_fd_pr__diode_pd2nw_05v5 area=1 perim=4 mult=1 m=1
M00190 (N00072 N00076 inh_hsupanalog inh_bulkpanalog) sky130_fd_pr__pfet_g5v0d10v5 w=1.075 l=0.5 nf=1 mult=1 ad=0.31175 as=0.31175 pd=2.73 ps=2.73 sa=0 sb=0 sd=0 m=1
M00191 (N00072 N00077 inh_hsupanalog inh_bulkpanalog) sky130_fd_pr__pfet_g5v0d10v5 w=1.075 l=0.5 nf=1 mult=1 ad=0.31175 as=0.31175 pd=2.73 ps=2.73 sa=0 sb=0 sd=0 m=1
M00192 (N00078 N00076 inh_lSup inh_lSup) sky130_fd_pr__nfet_g5v0d10v5 w=1.075 l=0.5 nf=1 mult=1 ad=0.31175 as=0.31175 pd=2.73 ps=2.73 sa=0 sb=0 sd=0 m=1
M00193 (N00072 N00077 N00078 inh_lSup) sky130_fd_pr__nfet_g5v0d10v5 w=1.075 l=0.5 nf=1 mult=1 ad=0.31175 as=0.31175 pd=2.73 ps=2.73 sa=0 sb=0 sd=0 m=1
D00194 (inh_lSup inh_hsupanalog) sky130_fd_pr__diode_pd2nw_05v5 area=1 perim=4 mult=1 m=1
M00195 (N00074 N00076 inh_hsupanalog inh_bulkpanalog) sky130_fd_pr__pfet_g5v0d10v5 w=1.075 l=0.5 nf=1 mult=1 ad=0.31175 as=0.31175 pd=2.73 ps=2.73 sa=0 sb=0 sd=0 m=1
M00196 (N00074 N00079 inh_hsupanalog inh_bulkpanalog) sky130_fd_pr__pfet_g5v0d10v5 w=1.075 l=0.5 nf=1 mult=1 ad=0.31175 as=0.31175 pd=2.73 ps=2.73 sa=0 sb=0 sd=0 m=1
M00197 (N00080 N00076 inh_lSup inh_lSup) sky130_fd_pr__nfet_g5v0d10v5 w=1.075 l=0.5 nf=1 mult=1 ad=0.31175 as=0.31175 pd=2.73 ps=2.73 sa=0 sb=0 sd=0 m=1
M00198 (N00074 N00079 N00080 inh_lSup) sky130_fd_pr__nfet_g5v0d10v5 w=1.075 l=0.5 nf=1 mult=1 ad=0.31175 as=0.31175 pd=2.73 ps=2.73 sa=0 sb=0 sd=0 m=1
D00199 (inh_lSup inh_hsupanalog) sky130_fd_pr__diode_pd2nw_05v5 area=1 perim=4 mult=1 m=1
M00200 (N00076 N00066 inh_hsupanalog inh_bulkpanalog) sky130_fd_pr__pfet_g5v0d10v5 w=1.075 l=0.5 nf=1 mult=1 ad=0.31175 as=0.31175 pd=2.73 ps=2.73 sa=0 sb=0 sd=0 m=1
M00201 (N00076 N00066 inh_hsupanalog inh_bulkpanalog) sky130_fd_pr__pfet_g5v0d10v5 w=1.075 l=0.5 nf=1 mult=1 ad=0.31175 as=0.31175 pd=2.73 ps=2.73 sa=0 sb=0 sd=0 m=1
M00202 (N00081 N00066 inh_lSup inh_lSup) sky130_fd_pr__nfet_g5v0d10v5 w=1.075 l=0.5 nf=1 mult=1 ad=0.31175 as=0.31175 pd=2.73 ps=2.73 sa=0 sb=0 sd=0 m=1
M00203 (N00076 N00066 N00081 inh_lSup) sky130_fd_pr__nfet_g5v0d10v5 w=1.075 l=0.5 nf=1 mult=1 ad=0.31175 as=0.31175 pd=2.73 ps=2.73 sa=0 sb=0 sd=0 m=1
D00204 (inh_lSup inh_hsupanalog) sky130_fd_pr__diode_pd2nw_05v5 area=1 perim=4 mult=1 m=1
M00205 (N00082 N00066 inh_hsupanalog inh_bulkpanalog) sky130_fd_pr__pfet_g5v0d10v5 w=1.075 l=0.5 nf=1 mult=1 ad=0.31175 as=0.31175 pd=2.73 ps=2.73 sa=0 sb=0 sd=0 m=1
M00206 (N00082 N00071 inh_hsupanalog inh_bulkpanalog) sky130_fd_pr__pfet_g5v0d10v5 w=1.075 l=0.5 nf=1 mult=1 ad=0.31175 as=0.31175 pd=2.73 ps=2.73 sa=0 sb=0 sd=0 m=1
M00207 (N00083 N00066 inh_lSup inh_lSup) sky130_fd_pr__nfet_g5v0d10v5 w=1.075 l=0.5 nf=1 mult=1 ad=0.31175 as=0.31175 pd=2.73 ps=2.73 sa=0 sb=0 sd=0 m=1
M00208 (N00082 N00071 N00083 inh_lSup) sky130_fd_pr__nfet_g5v0d10v5 w=1.075 l=0.5 nf=1 mult=1 ad=0.31175 as=0.31175 pd=2.73 ps=2.73 sa=0 sb=0 sd=0 m=1
D00209 (inh_lSup inh_hsupanalog) sky130_fd_pr__diode_pd2nw_05v5 area=1 perim=4 mult=1 m=1
M00210 (N00077 N00079 inh_hsupanalog inh_bulkpanalog) sky130_fd_pr__pfet_g5v0d10v5 w=1.075 l=0.5 nf=1 mult=1 ad=0.31175 as=0.31175 pd=2.73 ps=2.73 sa=0 sb=0 sd=0 m=1
M00211 (N00077 N00082 inh_hsupanalog inh_bulkpanalog) sky130_fd_pr__pfet_g5v0d10v5 w=1.075 l=0.5 nf=1 mult=1 ad=0.31175 as=0.31175 pd=2.73 ps=2.73 sa=0 sb=0 sd=0 m=1
M00212 (N00084 N00079 inh_lSup inh_lSup) sky130_fd_pr__nfet_g5v0d10v5 w=1.075 l=0.5 nf=1 mult=1 ad=0.31175 as=0.31175 pd=2.73 ps=2.73 sa=0 sb=0 sd=0 m=1
M00213 (N00077 N00082 N00084 inh_lSup) sky130_fd_pr__nfet_g5v0d10v5 w=1.075 l=0.5 nf=1 mult=1 ad=0.31175 as=0.31175 pd=2.73 ps=2.73 sa=0 sb=0 sd=0 m=1
D00214 (inh_lSup inh_hsupanalog) sky130_fd_pr__diode_pd2nw_05v5 area=1 perim=4 mult=1 m=1
M00215 (N00079 N00077 inh_hsupanalog inh_bulkpanalog) sky130_fd_pr__pfet_g5v0d10v5 w=1.075 l=0.5 nf=1 mult=1 ad=0.31175 as=0.31175 pd=2.73 ps=2.73 sa=0 sb=0 sd=0 m=1
M00216 (N00079 N00085 inh_hsupanalog inh_bulkpanalog) sky130_fd_pr__pfet_g5v0d10v5 w=1.075 l=0.5 nf=1 mult=1 ad=0.31175 as=0.31175 pd=2.73 ps=2.73 sa=0 sb=0 sd=0 m=1
M00217 (N00086 N00077 inh_lSup inh_lSup) sky130_fd_pr__nfet_g5v0d10v5 w=1.075 l=0.5 nf=1 mult=1 ad=0.31175 as=0.31175 pd=2.73 ps=2.73 sa=0 sb=0 sd=0 m=1
M00218 (N00079 N00085 N00086 inh_lSup) sky130_fd_pr__nfet_g5v0d10v5 w=1.075 l=0.5 nf=1 mult=1 ad=0.31175 as=0.31175 pd=2.73 ps=2.73 sa=0 sb=0 sd=0 m=1
D00219 (inh_lSup inh_hsupanalog) sky130_fd_pr__diode_pd2nw_05v5 area=1 perim=4 mult=1 m=1
M00220 (N00085 N00066 inh_hsupanalog inh_bulkpanalog) sky130_fd_pr__pfet_g5v0d10v5 w=1.075 l=0.5 nf=1 mult=1 ad=0.31175 as=0.31175 pd=2.73 ps=2.73 sa=0 sb=0 sd=0 m=1
M00221 (N00085 N00070 inh_hsupanalog inh_bulkpanalog) sky130_fd_pr__pfet_g5v0d10v5 w=1.075 l=0.5 nf=1 mult=1 ad=0.31175 as=0.31175 pd=2.73 ps=2.73 sa=0 sb=0 sd=0 m=1
M00222 (N00087 N00066 inh_lSup inh_lSup) sky130_fd_pr__nfet_g5v0d10v5 w=1.075 l=0.5 nf=1 mult=1 ad=0.31175 as=0.31175 pd=2.73 ps=2.73 sa=0 sb=0 sd=0 m=1
M00223 (N00085 N00070 N00087 inh_lSup) sky130_fd_pr__nfet_g5v0d10v5 w=1.075 l=0.5 nf=1 mult=1 ad=0.31175 as=0.31175 pd=2.73 ps=2.73 sa=0 sb=0 sd=0 m=1
D00224 (inh_lSup inh_hsupanalog) sky130_fd_pr__diode_pd2nw_05v5 area=1 perim=4 mult=1 m=1
M00225 (N00019 N00014 inh_hsupanalog inh_bulkpanalog) sky130_fd_pr__pfet_g5v0d10v5 w=1.075 l=0.5 nf=1 mult=1 ad=0.31175 as=0.31175 pd=2.73 ps=2.73 sa=0 sb=0 sd=0 m=1
M00226 (N00019 N00088 inh_hsupanalog inh_bulkpanalog) sky130_fd_pr__pfet_g5v0d10v5 w=1.075 l=0.5 nf=1 mult=1 ad=0.31175 as=0.31175 pd=2.73 ps=2.73 sa=0 sb=0 sd=0 m=1
M00227 (N00089 N00014 inh_lSup inh_lSup) sky130_fd_pr__nfet_g5v0d10v5 w=1.075 l=0.5 nf=1 mult=1 ad=0.31175 as=0.31175 pd=2.73 ps=2.73 sa=0 sb=0 sd=0 m=1
M00228 (N00019 N00088 N00089 inh_lSup) sky130_fd_pr__nfet_g5v0d10v5 w=1.075 l=0.5 nf=1 mult=1 ad=0.31175 as=0.31175 pd=2.73 ps=2.73 sa=0 sb=0 sd=0 m=1
D00229 (inh_lSup inh_hsupanalog) sky130_fd_pr__diode_pd2nw_05v5 area=1 perim=4 mult=1 m=1
M00230 (N00014 N00019 inh_hsupanalog inh_bulkpanalog) sky130_fd_pr__pfet_g5v0d10v5 w=1.075 l=0.5 nf=1 mult=1 ad=0.31175 as=0.31175 pd=2.73 ps=2.73 sa=0 sb=0 sd=0 m=1
M00231 (N00014 N00090 inh_hsupanalog inh_bulkpanalog) sky130_fd_pr__pfet_g5v0d10v5 w=1.075 l=0.5 nf=1 mult=1 ad=0.31175 as=0.31175 pd=2.73 ps=2.73 sa=0 sb=0 sd=0 m=1
M00232 (N00091 N00019 inh_lSup inh_lSup) sky130_fd_pr__nfet_g5v0d10v5 w=1.075 l=0.5 nf=1 mult=1 ad=0.31175 as=0.31175 pd=2.73 ps=2.73 sa=0 sb=0 sd=0 m=1
M00233 (N00014 N00090 N00091 inh_lSup) sky130_fd_pr__nfet_g5v0d10v5 w=1.075 l=0.5 nf=1 mult=1 ad=0.31175 as=0.31175 pd=2.73 ps=2.73 sa=0 sb=0 sd=0 m=1
D00234 (inh_lSup inh_hsupanalog) sky130_fd_pr__diode_pd2nw_05v5 area=1 perim=4 mult=1 m=1
M00235 (N00088 N00092 inh_hsupanalog inh_bulkpanalog) sky130_fd_pr__pfet_g5v0d10v5 w=1.075 l=0.5 nf=1 mult=1 ad=0.31175 as=0.31175 pd=2.73 ps=2.73 sa=0 sb=0 sd=0 m=1
M00236 (N00088 N00093 inh_hsupanalog inh_bulkpanalog) sky130_fd_pr__pfet_g5v0d10v5 w=1.075 l=0.5 nf=1 mult=1 ad=0.31175 as=0.31175 pd=2.73 ps=2.73 sa=0 sb=0 sd=0 m=1
M00237 (N00094 N00092 inh_lSup inh_lSup) sky130_fd_pr__nfet_g5v0d10v5 w=1.075 l=0.5 nf=1 mult=1 ad=0.31175 as=0.31175 pd=2.73 ps=2.73 sa=0 sb=0 sd=0 m=1
M00238 (N00088 N00093 N00094 inh_lSup) sky130_fd_pr__nfet_g5v0d10v5 w=1.075 l=0.5 nf=1 mult=1 ad=0.31175 as=0.31175 pd=2.73 ps=2.73 sa=0 sb=0 sd=0 m=1
D00239 (inh_lSup inh_hsupanalog) sky130_fd_pr__diode_pd2nw_05v5 area=1 perim=4 mult=1 m=1
M00240 (N00090 N00092 inh_hsupanalog inh_bulkpanalog) sky130_fd_pr__pfet_g5v0d10v5 w=1.075 l=0.5 nf=1 mult=1 ad=0.31175 as=0.31175 pd=2.73 ps=2.73 sa=0 sb=0 sd=0 m=1
M00241 (N00090 N00095 inh_hsupanalog inh_bulkpanalog) sky130_fd_pr__pfet_g5v0d10v5 w=1.075 l=0.5 nf=1 mult=1 ad=0.31175 as=0.31175 pd=2.73 ps=2.73 sa=0 sb=0 sd=0 m=1
M00242 (N00096 N00092 inh_lSup inh_lSup) sky130_fd_pr__nfet_g5v0d10v5 w=1.075 l=0.5 nf=1 mult=1 ad=0.31175 as=0.31175 pd=2.73 ps=2.73 sa=0 sb=0 sd=0 m=1
M00243 (N00090 N00095 N00096 inh_lSup) sky130_fd_pr__nfet_g5v0d10v5 w=1.075 l=0.5 nf=1 mult=1 ad=0.31175 as=0.31175 pd=2.73 ps=2.73 sa=0 sb=0 sd=0 m=1
D00244 (inh_lSup inh_hsupanalog) sky130_fd_pr__diode_pd2nw_05v5 area=1 perim=4 mult=1 m=1
M00245 (N00092 N00059 inh_hsupanalog inh_bulkpanalog) sky130_fd_pr__pfet_g5v0d10v5 w=1.075 l=0.5 nf=1 mult=1 ad=0.31175 as=0.31175 pd=2.73 ps=2.73 sa=0 sb=0 sd=0 m=1
M00246 (N00092 N00059 inh_hsupanalog inh_bulkpanalog) sky130_fd_pr__pfet_g5v0d10v5 w=1.075 l=0.5 nf=1 mult=1 ad=0.31175 as=0.31175 pd=2.73 ps=2.73 sa=0 sb=0 sd=0 m=1
M00247 (N00097 N00059 inh_lSup inh_lSup) sky130_fd_pr__nfet_g5v0d10v5 w=1.075 l=0.5 nf=1 mult=1 ad=0.31175 as=0.31175 pd=2.73 ps=2.73 sa=0 sb=0 sd=0 m=1
M00248 (N00092 N00059 N00097 inh_lSup) sky130_fd_pr__nfet_g5v0d10v5 w=1.075 l=0.5 nf=1 mult=1 ad=0.31175 as=0.31175 pd=2.73 ps=2.73 sa=0 sb=0 sd=0 m=1
D00249 (inh_lSup inh_hsupanalog) sky130_fd_pr__diode_pd2nw_05v5 area=1 perim=4 mult=1 m=1
M00250 (N00098 N00059 inh_hsupanalog inh_bulkpanalog) sky130_fd_pr__pfet_g5v0d10v5 w=1.075 l=0.5 nf=1 mult=1 ad=0.31175 as=0.31175 pd=2.73 ps=2.73 sa=0 sb=0 sd=0 m=1
M00251 (N00098 N00014 inh_hsupanalog inh_bulkpanalog) sky130_fd_pr__pfet_g5v0d10v5 w=1.075 l=0.5 nf=1 mult=1 ad=0.31175 as=0.31175 pd=2.73 ps=2.73 sa=0 sb=0 sd=0 m=1
M00252 (N00099 N00059 inh_lSup inh_lSup) sky130_fd_pr__nfet_g5v0d10v5 w=1.075 l=0.5 nf=1 mult=1 ad=0.31175 as=0.31175 pd=2.73 ps=2.73 sa=0 sb=0 sd=0 m=1
M00253 (N00098 N00014 N00099 inh_lSup) sky130_fd_pr__nfet_g5v0d10v5 w=1.075 l=0.5 nf=1 mult=1 ad=0.31175 as=0.31175 pd=2.73 ps=2.73 sa=0 sb=0 sd=0 m=1
D00254 (inh_lSup inh_hsupanalog) sky130_fd_pr__diode_pd2nw_05v5 area=1 perim=4 mult=1 m=1
M00255 (N00093 N00095 inh_hsupanalog inh_bulkpanalog) sky130_fd_pr__pfet_g5v0d10v5 w=1.075 l=0.5 nf=1 mult=1 ad=0.31175 as=0.31175 pd=2.73 ps=2.73 sa=0 sb=0 sd=0 m=1
M00256 (N00093 N00098 inh_hsupanalog inh_bulkpanalog) sky130_fd_pr__pfet_g5v0d10v5 w=1.075 l=0.5 nf=1 mult=1 ad=0.31175 as=0.31175 pd=2.73 ps=2.73 sa=0 sb=0 sd=0 m=1
M00257 (N00100 N00095 inh_lSup inh_lSup) sky130_fd_pr__nfet_g5v0d10v5 w=1.075 l=0.5 nf=1 mult=1 ad=0.31175 as=0.31175 pd=2.73 ps=2.73 sa=0 sb=0 sd=0 m=1
M00258 (N00093 N00098 N00100 inh_lSup) sky130_fd_pr__nfet_g5v0d10v5 w=1.075 l=0.5 nf=1 mult=1 ad=0.31175 as=0.31175 pd=2.73 ps=2.73 sa=0 sb=0 sd=0 m=1
D00259 (inh_lSup inh_hsupanalog) sky130_fd_pr__diode_pd2nw_05v5 area=1 perim=4 mult=1 m=1
M00260 (N00095 N00093 inh_hsupanalog inh_bulkpanalog) sky130_fd_pr__pfet_g5v0d10v5 w=1.075 l=0.5 nf=1 mult=1 ad=0.31175 as=0.31175 pd=2.73 ps=2.73 sa=0 sb=0 sd=0 m=1
M00261 (N00095 N00101 inh_hsupanalog inh_bulkpanalog) sky130_fd_pr__pfet_g5v0d10v5 w=1.075 l=0.5 nf=1 mult=1 ad=0.31175 as=0.31175 pd=2.73 ps=2.73 sa=0 sb=0 sd=0 m=1
M00262 (N00102 N00093 inh_lSup inh_lSup) sky130_fd_pr__nfet_g5v0d10v5 w=1.075 l=0.5 nf=1 mult=1 ad=0.31175 as=0.31175 pd=2.73 ps=2.73 sa=0 sb=0 sd=0 m=1
M00263 (N00095 N00101 N00102 inh_lSup) sky130_fd_pr__nfet_g5v0d10v5 w=1.075 l=0.5 nf=1 mult=1 ad=0.31175 as=0.31175 pd=2.73 ps=2.73 sa=0 sb=0 sd=0 m=1
D00264 (inh_lSup inh_hsupanalog) sky130_fd_pr__diode_pd2nw_05v5 area=1 perim=4 mult=1 m=1
M00265 (N00101 N00059 inh_hsupanalog inh_bulkpanalog) sky130_fd_pr__pfet_g5v0d10v5 w=1.075 l=0.5 nf=1 mult=1 ad=0.31175 as=0.31175 pd=2.73 ps=2.73 sa=0 sb=0 sd=0 m=1
M00266 (N00101 N00019 inh_hsupanalog inh_bulkpanalog) sky130_fd_pr__pfet_g5v0d10v5 w=1.075 l=0.5 nf=1 mult=1 ad=0.31175 as=0.31175 pd=2.73 ps=2.73 sa=0 sb=0 sd=0 m=1
M00267 (N00103 N00059 inh_lSup inh_lSup) sky130_fd_pr__nfet_g5v0d10v5 w=1.075 l=0.5 nf=1 mult=1 ad=0.31175 as=0.31175 pd=2.73 ps=2.73 sa=0 sb=0 sd=0 m=1
M00268 (N00101 N00019 N00103 inh_lSup) sky130_fd_pr__nfet_g5v0d10v5 w=1.075 l=0.5 nf=1 mult=1 ad=0.31175 as=0.31175 pd=2.73 ps=2.73 sa=0 sb=0 sd=0 m=1
D00269 (inh_lSup inh_hsupanalog) sky130_fd_pr__diode_pd2nw_05v5 area=1 perim=4 mult=1 m=1
M00270 (N00104 N00105 N00106 inh_bulkn) sky130_fd_pr__nfet_g5v0d10v5 w=0.5 l=0.5 nf=1 mult=1 ad=0.145 as=0.145 pd=1.58 ps=1.58 sa=0 sb=0 sd=0 m=1
M00271 (N00106 N00107 N00104 inh_bulkpanalog) sky130_fd_pr__pfet_g5v0d10v5 w=0.5 l=0.5 nf=1 mult=1 ad=0.145 as=0.145 pd=1.58 ps=1.58 sa=0 sb=0 sd=0 m=1
M00272 (N00067 N00105 N00108 inh_bulkn) sky130_fd_pr__nfet_g5v0d10v5 w=0.5 l=0.5 nf=1 mult=1 ad=0.145 as=0.145 pd=1.58 ps=1.58 sa=0 sb=0 sd=0 m=1
M00273 (N00108 N00107 N00067 inh_bulkpanalog) sky130_fd_pr__pfet_g5v0d10v5 w=0.5 l=0.5 nf=1 mult=1 ad=0.145 as=0.145 pd=1.58 ps=1.58 sa=0 sb=0 sd=0 m=1
M00274 (N00104 N00109 N00108 inh_bulkn) sky130_fd_pr__nfet_g5v0d10v5 w=0.5 l=0.5 nf=1 mult=1 ad=0.145 as=0.145 pd=1.58 ps=1.58 sa=0 sb=0 sd=0 m=1
M00275 (N00108 N00110 N00104 inh_bulkpanalog) sky130_fd_pr__pfet_g5v0d10v5 w=0.5 l=0.5 nf=1 mult=1 ad=0.145 as=0.145 pd=1.58 ps=1.58 sa=0 sb=0 sd=0 m=1
M00276 (N00111 N00105 N00112 inh_bulkn) sky130_fd_pr__nfet_g5v0d10v5 w=0.5 l=0.5 nf=1 mult=1 ad=0.145 as=0.145 pd=1.58 ps=1.58 sa=0 sb=0 sd=0 m=1
M00277 (N00112 N00107 N00111 inh_bulkpanalog) sky130_fd_pr__pfet_g5v0d10v5 w=0.5 l=0.5 nf=1 mult=1 ad=0.145 as=0.145 pd=1.58 ps=1.58 sa=0 sb=0 sd=0 m=1
M00278 (N00112 N00109 N00113 inh_bulkn) sky130_fd_pr__nfet_g5v0d10v5 w=0.5 l=0.5 nf=1 mult=1 ad=0.145 as=0.145 pd=1.58 ps=1.58 sa=0 sb=0 sd=0 m=1
M00279 (N00113 N00110 N00112 inh_bulkpanalog) sky130_fd_pr__pfet_g5v0d10v5 w=0.5 l=0.5 nf=1 mult=1 ad=0.145 as=0.145 pd=1.58 ps=1.58 sa=0 sb=0 sd=0 m=1
M00280 (N00111 N00109 N00114 inh_bulkn) sky130_fd_pr__nfet_g5v0d10v5 w=0.5 l=0.5 nf=1 mult=1 ad=0.145 as=0.145 pd=1.58 ps=1.58 sa=0 sb=0 sd=0 m=1
M00281 (N00114 N00110 N00111 inh_bulkpanalog) sky130_fd_pr__pfet_g5v0d10v5 w=0.5 l=0.5 nf=1 mult=1 ad=0.145 as=0.145 pd=1.58 ps=1.58 sa=0 sb=0 sd=0 m=1
M00282 (N00114 N00105 N00113 inh_bulkn) sky130_fd_pr__nfet_g5v0d10v5 w=0.5 l=0.5 nf=1 mult=1 ad=0.145 as=0.145 pd=1.58 ps=1.58 sa=0 sb=0 sd=0 m=1
M00283 (N00113 N00107 N00114 inh_bulkpanalog) sky130_fd_pr__pfet_g5v0d10v5 w=0.5 l=0.5 nf=1 mult=1 ad=0.145 as=0.145 pd=1.58 ps=1.58 sa=0 sb=0 sd=0 m=1
M00284 (N00067 N00109 N00106 inh_bulkn) sky130_fd_pr__nfet_g5v0d10v5 w=0.5 l=0.5 nf=1 mult=1 ad=0.145 as=0.145 pd=1.58 ps=1.58 sa=0 sb=0 sd=0 m=1
M00285 (N00106 N00110 N00067 inh_bulkpanalog) sky130_fd_pr__pfet_g5v0d10v5 w=0.5 l=0.5 nf=1 mult=1 ad=0.145 as=0.145 pd=1.58 ps=1.58 sa=0 sb=0 sd=0 m=1
M00286 (N00064 inh_lSup N00115 inh_bulkpanalog) sky130_fd_pr__pfet_g5v0d10v5 w=0.42 l=10.5 nf=1 mult=1 ad=0.1218 as=0.1218 pd=1.42 ps=1.42 sa=0 sb=0 sd=0 m=1
M00287 (N00111 N00116 inh_hsupanalog inh_bulkpanalog) sky130_fd_pr__pfet_g5v0d10v5 w=0.85 l=0.5 nf=1 mult=1 ad=0.2465 as=0.2465 pd=2.28 ps=2.28 sa=0 sb=0 sd=0 m=1
M00288 (N00113 N00116 inh_hsupanalog inh_bulkpanalog) sky130_fd_pr__pfet_g5v0d10v5 w=0.85 l=0.5 nf=1 mult=1 ad=0.2465 as=0.2465 pd=2.28 ps=2.28 sa=0 sb=0 sd=0 m=1
M00289 (N00114 N00116 inh_hsupanalog inh_bulkpanalog) sky130_fd_pr__pfet_g5v0d10v5 w=0.85 l=0.5 nf=1 mult=1 ad=0.2465 as=0.2465 pd=2.28 ps=2.28 sa=0 sb=0 sd=0 m=1
M00290 (N00112 N00116 inh_hsupanalog inh_bulkpanalog) sky130_fd_pr__pfet_g5v0d10v5 w=0.85 l=0.5 nf=1 mult=1 ad=0.2465 as=0.2465 pd=2.28 ps=2.28 sa=0 sb=0 sd=0 m=1
M00291 (N00112 N00111 inh_hsupanalog inh_bulkpanalog) sky130_fd_pr__pfet_g5v0d10v5 w=3 l=0.8 nf=1 mult=1 ad=0.87 as=0.87 pd=6.58 ps=6.58 sa=0 sb=0 sd=0 m=1
M00292 (N00114 N00111 inh_hsupanalog inh_bulkpanalog) sky130_fd_pr__pfet_g5v0d10v5 w=3 l=0.8 nf=1 mult=1 ad=0.87 as=0.87 pd=6.58 ps=6.58 sa=0 sb=0 sd=0 m=1
M00293 (N00064 N00113 inh_hsupanalog inh_bulkpanalog) sky130_fd_pr__pfet_g5v0d10v5 w=3 l=0.8 nf=1 mult=20 ad=0.87 as=0.87 pd=6.58 ps=6.58 sa=0 sb=0 sd=0 m=20
M00294 (N00064 N00117 inh_lSup inh_bulkn) sky130_fd_pr__nfet_g5v0d10v5 w=0.85 l=0.5 nf=1 mult=1 ad=0.2465 as=0.2465 pd=2.28 ps=2.28 sa=0 sb=0 sd=0 m=1
M00295 (N00118 N00117 inh_lSup inh_bulkn) sky130_fd_pr__nfet_g5v0d10v5 w=0.85 l=0.5 nf=1 mult=1 ad=0.2465 as=0.2465 pd=2.28 ps=2.28 sa=0 sb=0 sd=0 m=1
M00296 (N00119 N00119 inh_lSup inh_bulkn) sky130_fd_pr__nfet_g5v0d10v5 w=3.75 l=0.5 nf=1 mult=1 ad=1.0875 as=1.0875 pd=8.08 ps=8.08 sa=0 sb=0 sd=0 m=1
M00297 (N00120 N00117 inh_lSup inh_bulkn) sky130_fd_pr__nfet_g5v0d10v5 w=0.85 l=0.5 nf=1 mult=1 ad=0.2465 as=0.2465 pd=2.28 ps=2.28 sa=0 sb=0 sd=0 m=1
M00298 (N00118 N00119 inh_lSup inh_bulkn) sky130_fd_pr__nfet_g5v0d10v5 w=3.75 l=0.5 nf=1 mult=1 ad=1.0875 as=1.0875 pd=8.08 ps=8.08 sa=0 sb=0 sd=0 m=1
M00299 (N00108 N00117 inh_lSup inh_bulkn) sky130_fd_pr__nfet_g5v0d10v5 w=0.85 l=0.5 nf=1 mult=1 ad=0.2465 as=0.2465 pd=2.28 ps=2.28 sa=0 sb=0 sd=0 m=1
M00300 (N00115 inh_hsupanalog N00064 inh_bulkn) sky130_fd_pr__nfet_g5v0d10v5 w=0.42 l=10.5 nf=1 mult=1 ad=0.1218 as=0.1218 pd=1.42 ps=1.42 sa=0 sb=0 sd=0 m=1
M00301 (ibp_1u_ai ibp_1u_ai N00119 inh_bulkn) sky130_fd_pr__nfet_g5v0d10v5 w=5 l=0.5 nf=1 mult=1 ad=1.45 as=1.45 pd=10.58 ps=10.58 sa=0 sb=0 sd=0 m=1
M00302 (N00106 N00117 inh_lSup inh_bulkn) sky130_fd_pr__nfet_g5v0d10v5 w=0.85 l=0.5 nf=1 mult=1 ad=0.2465 as=0.2465 pd=2.28 ps=2.28 sa=0 sb=0 sd=0 m=1
M00303 (N00114 N00106 N00120 inh_bulkn) sky130_fd_pr__nfet_g5v0d10v5 w=12.5 l=0.5 nf=1 mult=4 ad=3.625 as=3.625 pd=25.58 ps=25.58 sa=0 sb=0 sd=0 m=4
M00304 (N00119 N00117 inh_lSup inh_bulkn) sky130_fd_pr__nfet_g5v0d10v5 w=0.85 l=0.5 nf=1 mult=1 ad=0.2465 as=0.2465 pd=2.28 ps=2.28 sa=0 sb=0 sd=0 m=1
M00305 (N00120 ibp_1u_ai N00118 inh_bulkn) sky130_fd_pr__nfet_g5v0d10v5 w=5 l=0.5 nf=1 mult=1 ad=1.45 as=1.45 pd=10.58 ps=10.58 sa=0 sb=0 sd=0 m=1
M00306 (N00112 N00108 N00120 inh_bulkn) sky130_fd_pr__nfet_g5v0d10v5 w=12.5 l=0.5 nf=1 mult=4 ad=3.625 as=3.625 pd=25.58 ps=25.58 sa=0 sb=0 sd=0 m=4
M00307 (ibp_1u_ai N00117 inh_lSup inh_bulkn) sky130_fd_pr__nfet_g5v0d10v5 w=0.85 l=0.5 nf=1 mult=1 ad=0.2465 as=0.2465 pd=2.28 ps=2.28 sa=0 sb=0 sd=0 m=1
M00308 (N00121 N00119 inh_lSup inh_bulkn) sky130_fd_pr__nfet_g5v0d10v5 w=3.75 l=0.5 nf=1 mult=10 ad=1.0875 as=1.0875 pd=8.08 ps=8.08 sa=0 sb=0 sd=0 m=10
M00309 (N00064 ibp_1u_ai N00121 inh_bulkn) sky130_fd_pr__nfet_g5v0d10v5 w=5 l=0.5 nf=1 mult=10 ad=1.45 as=1.45 pd=10.58 ps=10.58 sa=0 sb=0 sd=0 m=10
M00310 (N00121 N00117 inh_lSup inh_bulkn) sky130_fd_pr__nfet_g5v0d10v5 w=0.85 l=0.5 nf=1 mult=1 ad=0.2465 as=0.2465 pd=2.28 ps=2.28 sa=0 sb=0 sd=0 m=1
M00311 (N00122 N00123 inh_hsupanalog inh_bulkpanalog) sky130_fd_pr__pfet_g5v0d10v5 w=1.725 l=0.5 nf=1 mult=1 ad=0.50025 as=0.50025 pd=4.03 ps=4.03 sa=0 sb=0 sd=0 m=1
M00312 (inh_hsupanalog N00122 inh_hsupanalog inh_bulkpanalog) sky130_fd_pr__pfet_g5v0d10v5 w=2.025 l=0.5 nf=1 mult=1 ad=0.58725 as=0.58725 pd=4.63 ps=4.63 sa=0 sb=0 sd=0 m=1
M00313 (N00124 N00122 inh_hsupanalog inh_bulkpanalog) sky130_fd_pr__pfet_g5v0d10v5 w=4.025 l=0.5 nf=1 mult=1 ad=1.16725 as=1.16725 pd=8.63 ps=8.63 sa=0 sb=0 sd=0 m=1
M00314 (inh_hsupanalog N00122 inh_hsupanalog inh_bulkpanalog) sky130_fd_pr__pfet_g5v0d10v5 w=2.025 l=0.5 nf=1 mult=1 ad=0.58725 as=0.58725 pd=4.63 ps=4.63 sa=0 sb=0 sd=0 m=1
M00315 (N00122 N00123 inh_lSup inh_bulkn) sky130_fd_pr__nfet_g5v0d10v5 w=0.42 l=0.56 nf=1 mult=1 ad=0.1218 as=0.1218 pd=1.42 ps=1.42 sa=0 sb=0 sd=0 m=1
M00316 (inh_lSup N00122 inh_lSup inh_bulkn) sky130_fd_pr__nfet_g5v0d10v5 w=1.4 l=0.5 nf=1 mult=1 ad=0.406 as=0.406 pd=3.38 ps=3.38 sa=0 sb=0 sd=0 m=1
M00317 (N00124 N00122 inh_lSup inh_bulkn) sky130_fd_pr__nfet_g5v0d10v5 w=0.875 l=0.5 nf=1 mult=1 ad=0.25375 as=0.25375 pd=2.33 ps=2.33 sa=0 sb=0 sd=0 m=1
M00318 (inh_lSup N00122 inh_lSup inh_bulkn) sky130_fd_pr__nfet_g5v0d10v5 w=1.4 l=0.5 nf=1 mult=1 ad=0.406 as=0.406 pd=3.38 ps=3.38 sa=0 sb=0 sd=0 m=1
D00319 (inh_lSup inh_hsupanalog) sky130_fd_pr__diode_pd2nw_05v5 area=1 perim=4 mult=1 m=1
M00320 (N00125 N00126 inh_hsupanalog inh_bulkpanalog) sky130_fd_pr__pfet_g5v0d10v5 w=1.725 l=0.5 nf=1 mult=1 ad=0.50025 as=0.50025 pd=4.03 ps=4.03 sa=0 sb=0 sd=0 m=1
M00321 (inh_hsupanalog N00125 inh_hsupanalog inh_bulkpanalog) sky130_fd_pr__pfet_g5v0d10v5 w=2.025 l=0.5 nf=1 mult=1 ad=0.58725 as=0.58725 pd=4.63 ps=4.63 sa=0 sb=0 sd=0 m=1
M00322 (N00127 N00125 inh_hsupanalog inh_bulkpanalog) sky130_fd_pr__pfet_g5v0d10v5 w=4.025 l=0.5 nf=1 mult=1 ad=1.16725 as=1.16725 pd=8.63 ps=8.63 sa=0 sb=0 sd=0 m=1
M00323 (inh_hsupanalog N00125 inh_hsupanalog inh_bulkpanalog) sky130_fd_pr__pfet_g5v0d10v5 w=2.025 l=0.5 nf=1 mult=1 ad=0.58725 as=0.58725 pd=4.63 ps=4.63 sa=0 sb=0 sd=0 m=1
M00324 (N00125 N00126 inh_lSup inh_bulkn) sky130_fd_pr__nfet_g5v0d10v5 w=0.42 l=0.56 nf=1 mult=1 ad=0.1218 as=0.1218 pd=1.42 ps=1.42 sa=0 sb=0 sd=0 m=1
M00325 (inh_lSup N00125 inh_lSup inh_bulkn) sky130_fd_pr__nfet_g5v0d10v5 w=1.4 l=0.5 nf=1 mult=1 ad=0.406 as=0.406 pd=3.38 ps=3.38 sa=0 sb=0 sd=0 m=1
M00326 (N00127 N00125 inh_lSup inh_bulkn) sky130_fd_pr__nfet_g5v0d10v5 w=0.875 l=0.5 nf=1 mult=1 ad=0.25375 as=0.25375 pd=2.33 ps=2.33 sa=0 sb=0 sd=0 m=1
M00327 (inh_lSup N00125 inh_lSup inh_bulkn) sky130_fd_pr__nfet_g5v0d10v5 w=1.4 l=0.5 nf=1 mult=1 ad=0.406 as=0.406 pd=3.38 ps=3.38 sa=0 sb=0 sd=0 m=1
D00328 (inh_lSup inh_hsupanalog) sky130_fd_pr__diode_pd2nw_05v5 area=1 perim=4 mult=1 m=1
M00329 (N00128 N00129 inh_hsupanalog inh_bulkpanalog) sky130_fd_pr__pfet_g5v0d10v5 w=2.875 l=0.5 nf=1 mult=1 ad=0.83375 as=0.83375 pd=6.33 ps=6.33 sa=0 sb=0 sd=0 m=1
M00330 (N00129 N00124 inh_hsupanalog inh_bulkpanalog) sky130_fd_pr__pfet_g5v0d10v5 w=2.875 l=0.5 nf=1 mult=1 ad=0.83375 as=0.83375 pd=6.33 ps=6.33 sa=0 sb=0 sd=0 m=1
M00331 (N00129 N00116 inh_hsupanalog inh_bulkpanalog) sky130_fd_pr__pfet_g5v0d10v5 w=2.875 l=0.5 nf=1 mult=1 ad=0.83375 as=0.83375 pd=6.33 ps=6.33 sa=0 sb=0 sd=0 m=1
M00332 (N00128 N00129 inh_lSup inh_bulkn) sky130_fd_pr__nfet_g5v0d10v5 w=0.625 l=0.5 nf=1 mult=1 ad=0.18125 as=0.18125 pd=1.83 ps=1.83 sa=0 sb=0 sd=0 m=1
M00333 (N00129 N00124 N00130 inh_bulkn) sky130_fd_pr__nfet_g5v0d10v5 w=0.625 l=0.5 nf=1 mult=1 ad=0.18125 as=0.18125 pd=1.83 ps=1.83 sa=0 sb=0 sd=0 m=1
M00334 (N00130 N00116 inh_lSup inh_bulkn) sky130_fd_pr__nfet_g5v0d10v5 w=0.625 l=0.5 nf=1 mult=1 ad=0.18125 as=0.18125 pd=1.83 ps=1.83 sa=0 sb=0 sd=0 m=1
D00335 (inh_lSup inh_hsupanalog) sky130_fd_pr__diode_pd2nw_05v5 area=1 perim=4 mult=1 m=1
M00336 (N00131 N00132 inh_hsupanalog inh_bulkpanalog) sky130_fd_pr__pfet_g5v0d10v5 w=2.875 l=0.5 nf=1 mult=1 ad=0.83375 as=0.83375 pd=6.33 ps=6.33 sa=0 sb=0 sd=0 m=1
M00337 (N00132 N00127 inh_hsupanalog inh_bulkpanalog) sky130_fd_pr__pfet_g5v0d10v5 w=2.875 l=0.5 nf=1 mult=1 ad=0.83375 as=0.83375 pd=6.33 ps=6.33 sa=0 sb=0 sd=0 m=1
M00338 (N00132 N00116 inh_hsupanalog inh_bulkpanalog) sky130_fd_pr__pfet_g5v0d10v5 w=2.875 l=0.5 nf=1 mult=1 ad=0.83375 as=0.83375 pd=6.33 ps=6.33 sa=0 sb=0 sd=0 m=1
M00339 (N00131 N00132 inh_lSup inh_bulkn) sky130_fd_pr__nfet_g5v0d10v5 w=0.625 l=0.5 nf=1 mult=1 ad=0.18125 as=0.18125 pd=1.83 ps=1.83 sa=0 sb=0 sd=0 m=1
M00340 (N00132 N00127 N00133 inh_bulkn) sky130_fd_pr__nfet_g5v0d10v5 w=0.625 l=0.5 nf=1 mult=1 ad=0.18125 as=0.18125 pd=1.83 ps=1.83 sa=0 sb=0 sd=0 m=1
M00341 (N00133 N00116 inh_lSup inh_bulkn) sky130_fd_pr__nfet_g5v0d10v5 w=0.625 l=0.5 nf=1 mult=1 ad=0.18125 as=0.18125 pd=1.83 ps=1.83 sa=0 sb=0 sd=0 m=1
D00342 (inh_lSup inh_hsupanalog) sky130_fd_pr__diode_pd2nw_05v5 area=1 perim=4 mult=1 m=1
M00343 (N00134 N00071 inh_hsupanalog inh_bulkpanalog) sky130_fd_pr__pfet_g5v0d10v5 w=2.875 l=0.5 nf=1 mult=1 ad=0.83375 as=0.83375 pd=6.33 ps=6.33 sa=0 sb=0 sd=0 m=1
M00344 (N00134 N00071 inh_lSup inh_lSup) sky130_fd_pr__nfet_g5v0d10v5 w=0.625 l=0.5 nf=1 mult=1 ad=0.18125 as=0.18125 pd=1.83 ps=1.83 sa=0 sb=0 sd=0 m=1
D00345 (inh_lSup inh_hsupanalog) sky130_fd_pr__diode_pd2nw_05v5 area=1 perim=4 mult=1 m=1
M00346 (N00117 N00015 inh_hsupanalog inh_bulkpanalog) sky130_fd_pr__pfet_g5v0d10v5 w=6.44 l=0.5 nf=1 mult=1 ad=1.8676 as=1.8676 pd=13.46 ps=13.46 sa=0 sb=0 sd=0 m=1
M00347 (N00117 N00015 inh_lSup inh_bulkn) sky130_fd_pr__nfet_g5v0d10v5 w=1.4 l=0.5 nf=1 mult=1 ad=0.406 as=0.406 pd=3.38 ps=3.38 sa=0 sb=0 sd=0 m=1
D00348 (inh_lSup inh_hsupanalog) sky130_fd_pr__diode_pd2nw_05v5 area=1 perim=4 mult=1 m=1
M00349 (N00123 N00071 inh_lSup inh_bulkn) sky130_fd_pr__nfet_g5v0d10v5 w=1.4 l=0.5 nf=1 mult=1 ad=0.406 as=0.406 pd=3.38 ps=3.38 sa=0 sb=0 sd=0 m=1
M00350 (N00123 N00127 inh_lSup inh_bulkn) sky130_fd_pr__nfet_g5v0d10v5 w=1.4 l=0.5 nf=1 mult=1 ad=0.406 as=0.406 pd=3.38 ps=3.38 sa=0 sb=0 sd=0 m=1
M00351 (N00123 N00071 N00135 inh_bulkpanalog) sky130_fd_pr__pfet_g5v0d10v5 w=6.44 l=0.5 nf=1 mult=1 ad=1.8676 as=1.8676 pd=13.46 ps=13.46 sa=0 sb=0 sd=0 m=1
M00352 (N00135 N00127 inh_hsupanalog inh_bulkpanalog) sky130_fd_pr__pfet_g5v0d10v5 w=6.44 l=0.5 nf=1 mult=1 ad=1.8676 as=1.8676 pd=13.46 ps=13.46 sa=0 sb=0 sd=0 m=1
D00353 (inh_lSup inh_hsupanalog) sky130_fd_pr__diode_pd2nw_05v5 area=1 perim=4 mult=1 m=1
M00354 (N00126 N00124 inh_lSup inh_bulkn) sky130_fd_pr__nfet_g5v0d10v5 w=1.4 l=0.5 nf=1 mult=1 ad=0.406 as=0.406 pd=3.38 ps=3.38 sa=0 sb=0 sd=0 m=1
M00355 (N00126 N00134 inh_lSup inh_bulkn) sky130_fd_pr__nfet_g5v0d10v5 w=1.4 l=0.5 nf=1 mult=1 ad=0.406 as=0.406 pd=3.38 ps=3.38 sa=0 sb=0 sd=0 m=1
M00356 (N00126 N00124 N00136 inh_bulkpanalog) sky130_fd_pr__pfet_g5v0d10v5 w=6.44 l=0.5 nf=1 mult=1 ad=1.8676 as=1.8676 pd=13.46 ps=13.46 sa=0 sb=0 sd=0 m=1
M00357 (N00136 N00134 inh_hsupanalog inh_bulkpanalog) sky130_fd_pr__pfet_g5v0d10v5 w=6.44 l=0.5 nf=1 mult=1 ad=1.8676 as=1.8676 pd=13.46 ps=13.46 sa=0 sb=0 sd=0 m=1
D00358 (inh_lSup inh_hsupanalog) sky130_fd_pr__diode_pd2nw_05v5 area=1 perim=4 mult=1 m=1
M00359 (N00137 N00015 inh_hsupanalog inh_bulkpanalog) sky130_fd_pr__pfet_g5v0d10v5 w=4.3 l=0.5 nf=1 mult=1 ad=1.247 as=1.247 pd=9.18 ps=9.18 sa=0 sb=0 sd=0 m=1
M00360 (N00116 N00137 inh_hsupanalog inh_bulkpanalog) sky130_fd_pr__pfet_g5v0d10v5 w=6.44 l=0.5 nf=1 mult=1 ad=1.8676 as=1.8676 pd=13.46 ps=13.46 sa=0 sb=0 sd=0 m=1
M00361 (N00137 N00015 inh_lSup inh_bulkn) sky130_fd_pr__nfet_g5v0d10v5 w=1.025 l=0.5 nf=1 mult=1 ad=0.29725 as=0.29725 pd=2.63 ps=2.63 sa=0 sb=0 sd=0 m=1
M00362 (N00116 N00137 inh_lSup inh_bulkn) sky130_fd_pr__nfet_g5v0d10v5 w=1.4 l=0.5 nf=1 mult=1 ad=0.406 as=0.406 pd=3.38 ps=3.38 sa=0 sb=0 sd=0 m=1
D00363 (inh_lSup inh_hsupanalog) sky130_fd_pr__diode_pd2nw_05v5 area=1 perim=4 mult=1 m=1
M00364 (N00138 inh_lSup N00139 inh_bulkpanalog) sky130_fd_pr__pfet_g5v0d10v5 w=2.875 l=0.5 nf=1 mult=1 ad=0.83375 as=0.83375 pd=6.33 ps=6.33 sa=0 sb=0 sd=0 m=1
M00365 (N00138 inh_hsupanalog N00139 inh_lSup) sky130_fd_pr__nfet_g5v0d10v5 w=0.625 l=0.5 nf=1 mult=1 ad=0.18125 as=0.18125 pd=1.83 ps=1.83 sa=0 sb=0 sd=0 m=1
M00366 (N00140 N00128 inh_hsupanalog inh_bulkpanalog) sky130_fd_pr__pfet_g5v0d10v5 w=2.875 l=0.5 nf=1 mult=1 ad=0.83375 as=0.83375 pd=6.33 ps=6.33 sa=0 sb=0 sd=0 m=1
M00367 (N00140 N00128 inh_lSup inh_lSup) sky130_fd_pr__nfet_g5v0d10v5 w=0.625 l=0.5 nf=1 mult=1 ad=0.18125 as=0.18125 pd=1.83 ps=1.83 sa=0 sb=0 sd=0 m=1
D00368 (inh_lSup inh_hsupanalog) sky130_fd_pr__diode_pd2nw_05v5 area=1 perim=4 mult=1 m=1
M00369 (N00141 N00140 inh_hsupanalog inh_bulkpanalog) sky130_fd_pr__pfet_g5v0d10v5 w=2.875 l=0.5 nf=1 mult=1 ad=0.83375 as=0.83375 pd=6.33 ps=6.33 sa=0 sb=0 sd=0 m=1
M00370 (N00141 N00140 inh_lSup inh_lSup) sky130_fd_pr__nfet_g5v0d10v5 w=0.625 l=0.5 nf=1 mult=1 ad=0.18125 as=0.18125 pd=1.83 ps=1.83 sa=0 sb=0 sd=0 m=1
D00371 (inh_lSup inh_hsupanalog) sky130_fd_pr__diode_pd2nw_05v5 area=1 perim=4 mult=1 m=1
M00372 (N00110 N00141 inh_hsupanalog inh_bulkpanalog) sky130_fd_pr__pfet_g5v0d10v5 w=2.875 l=0.5 nf=1 mult=1 ad=0.83375 as=0.83375 pd=6.33 ps=6.33 sa=0 sb=0 sd=0 m=1
M00373 (N00110 N00141 inh_lSup inh_lSup) sky130_fd_pr__nfet_g5v0d10v5 w=0.625 l=0.5 nf=1 mult=1 ad=0.18125 as=0.18125 pd=1.83 ps=1.83 sa=0 sb=0 sd=0 m=1
D00374 (inh_lSup inh_hsupanalog) sky130_fd_pr__diode_pd2nw_05v5 area=1 perim=4 mult=1 m=1
M00375 (N00109 N00139 inh_hsupanalog inh_bulkpanalog) sky130_fd_pr__pfet_g5v0d10v5 w=2.875 l=0.5 nf=1 mult=1 ad=0.83375 as=0.83375 pd=6.33 ps=6.33 sa=0 sb=0 sd=0 m=1
M00376 (N00109 N00139 inh_lSup inh_lSup) sky130_fd_pr__nfet_g5v0d10v5 w=0.625 l=0.5 nf=1 mult=1 ad=0.18125 as=0.18125 pd=1.83 ps=1.83 sa=0 sb=0 sd=0 m=1
D00377 (inh_lSup inh_hsupanalog) sky130_fd_pr__diode_pd2nw_05v5 area=1 perim=4 mult=1 m=1
M00378 (N00138 N00128 inh_hsupanalog inh_bulkpanalog) sky130_fd_pr__pfet_g5v0d10v5 w=2.875 l=0.5 nf=1 mult=1 ad=0.83375 as=0.83375 pd=6.33 ps=6.33 sa=0 sb=0 sd=0 m=1
M00379 (N00138 N00128 inh_lSup inh_lSup) sky130_fd_pr__nfet_g5v0d10v5 w=0.625 l=0.5 nf=1 mult=1 ad=0.18125 as=0.18125 pd=1.83 ps=1.83 sa=0 sb=0 sd=0 m=1
D00380 (inh_lSup inh_hsupanalog) sky130_fd_pr__diode_pd2nw_05v5 area=1 perim=4 mult=1 m=1
M00381 (N00141 N00139 inh_hsupanalog inh_bulkpanalog) sky130_fd_pr__pfet_g5v0d10v5 w=2.3 l=1 nf=1 mult=1 ad=0.667 as=0.667 pd=5.18 ps=5.18 sa=0 sb=0 sd=0 m=1
M00382 (N00141 N00139 inh_lSup inh_lSup) sky130_fd_pr__nfet_g5v0d10v5 w=0.5 l=1 nf=1 mult=1 ad=0.145 as=0.145 pd=1.58 ps=1.58 sa=0 sb=0 sd=0 m=1
D00383 (inh_lSup inh_hsupanalog) sky130_fd_pr__diode_pd2nw_05v5 area=1 perim=4 mult=1 m=1
M00384 (N00110 N00109 inh_hsupanalog inh_bulkpanalog) sky130_fd_pr__pfet_g5v0d10v5 w=2.3 l=1 nf=1 mult=1 ad=0.667 as=0.667 pd=5.18 ps=5.18 sa=0 sb=0 sd=0 m=1
M00385 (N00110 N00109 inh_lSup inh_lSup) sky130_fd_pr__nfet_g5v0d10v5 w=0.5 l=1 nf=1 mult=1 ad=0.145 as=0.145 pd=1.58 ps=1.58 sa=0 sb=0 sd=0 m=1
D00386 (inh_lSup inh_hsupanalog) sky130_fd_pr__diode_pd2nw_05v5 area=1 perim=4 mult=1 m=1
M00387 (N00139 N00141 inh_hsupanalog inh_bulkpanalog) sky130_fd_pr__pfet_g5v0d10v5 w=2.3 l=1 nf=1 mult=1 ad=0.667 as=0.667 pd=5.18 ps=5.18 sa=0 sb=0 sd=0 m=1
M00388 (N00139 N00141 inh_lSup inh_lSup) sky130_fd_pr__nfet_g5v0d10v5 w=0.5 l=1 nf=1 mult=1 ad=0.145 as=0.145 pd=1.58 ps=1.58 sa=0 sb=0 sd=0 m=1
D00389 (inh_lSup inh_hsupanalog) sky130_fd_pr__diode_pd2nw_05v5 area=1 perim=4 mult=1 m=1
M00390 (N00109 N00110 inh_hsupanalog inh_bulkpanalog) sky130_fd_pr__pfet_g5v0d10v5 w=2.3 l=1 nf=1 mult=1 ad=0.667 as=0.667 pd=5.18 ps=5.18 sa=0 sb=0 sd=0 m=1
M00391 (N00109 N00110 inh_lSup inh_lSup) sky130_fd_pr__nfet_g5v0d10v5 w=0.5 l=1 nf=1 mult=1 ad=0.145 as=0.145 pd=1.58 ps=1.58 sa=0 sb=0 sd=0 m=1
D00392 (inh_lSup inh_hsupanalog) sky130_fd_pr__diode_pd2nw_05v5 area=1 perim=4 mult=1 m=1
M00393 (N00142 inh_lSup N00143 inh_bulkpanalog) sky130_fd_pr__pfet_g5v0d10v5 w=2.875 l=0.5 nf=1 mult=1 ad=0.83375 as=0.83375 pd=6.33 ps=6.33 sa=0 sb=0 sd=0 m=1
M00394 (N00142 inh_hsupanalog N00143 inh_lSup) sky130_fd_pr__nfet_g5v0d10v5 w=0.625 l=0.5 nf=1 mult=1 ad=0.18125 as=0.18125 pd=1.83 ps=1.83 sa=0 sb=0 sd=0 m=1
M00395 (N00144 N00131 inh_hsupanalog inh_bulkpanalog) sky130_fd_pr__pfet_g5v0d10v5 w=2.875 l=0.5 nf=1 mult=1 ad=0.83375 as=0.83375 pd=6.33 ps=6.33 sa=0 sb=0 sd=0 m=1
M00396 (N00144 N00131 inh_lSup inh_lSup) sky130_fd_pr__nfet_g5v0d10v5 w=0.625 l=0.5 nf=1 mult=1 ad=0.18125 as=0.18125 pd=1.83 ps=1.83 sa=0 sb=0 sd=0 m=1
D00397 (inh_lSup inh_hsupanalog) sky130_fd_pr__diode_pd2nw_05v5 area=1 perim=4 mult=1 m=1
M00398 (N00145 N00144 inh_hsupanalog inh_bulkpanalog) sky130_fd_pr__pfet_g5v0d10v5 w=2.875 l=0.5 nf=1 mult=1 ad=0.83375 as=0.83375 pd=6.33 ps=6.33 sa=0 sb=0 sd=0 m=1
M00399 (N00145 N00144 inh_lSup inh_lSup) sky130_fd_pr__nfet_g5v0d10v5 w=0.625 l=0.5 nf=1 mult=1 ad=0.18125 as=0.18125 pd=1.83 ps=1.83 sa=0 sb=0 sd=0 m=1
D00400 (inh_lSup inh_hsupanalog) sky130_fd_pr__diode_pd2nw_05v5 area=1 perim=4 mult=1 m=1
M00401 (N00107 N00145 inh_hsupanalog inh_bulkpanalog) sky130_fd_pr__pfet_g5v0d10v5 w=2.875 l=0.5 nf=1 mult=1 ad=0.83375 as=0.83375 pd=6.33 ps=6.33 sa=0 sb=0 sd=0 m=1
M00402 (N00107 N00145 inh_lSup inh_lSup) sky130_fd_pr__nfet_g5v0d10v5 w=0.625 l=0.5 nf=1 mult=1 ad=0.18125 as=0.18125 pd=1.83 ps=1.83 sa=0 sb=0 sd=0 m=1
D00403 (inh_lSup inh_hsupanalog) sky130_fd_pr__diode_pd2nw_05v5 area=1 perim=4 mult=1 m=1
M00404 (N00105 N00143 inh_hsupanalog inh_bulkpanalog) sky130_fd_pr__pfet_g5v0d10v5 w=2.875 l=0.5 nf=1 mult=1 ad=0.83375 as=0.83375 pd=6.33 ps=6.33 sa=0 sb=0 sd=0 m=1
M00405 (N00105 N00143 inh_lSup inh_lSup) sky130_fd_pr__nfet_g5v0d10v5 w=0.625 l=0.5 nf=1 mult=1 ad=0.18125 as=0.18125 pd=1.83 ps=1.83 sa=0 sb=0 sd=0 m=1
D00406 (inh_lSup inh_hsupanalog) sky130_fd_pr__diode_pd2nw_05v5 area=1 perim=4 mult=1 m=1
M00407 (N00142 N00131 inh_hsupanalog inh_bulkpanalog) sky130_fd_pr__pfet_g5v0d10v5 w=2.875 l=0.5 nf=1 mult=1 ad=0.83375 as=0.83375 pd=6.33 ps=6.33 sa=0 sb=0 sd=0 m=1
M00408 (N00142 N00131 inh_lSup inh_lSup) sky130_fd_pr__nfet_g5v0d10v5 w=0.625 l=0.5 nf=1 mult=1 ad=0.18125 as=0.18125 pd=1.83 ps=1.83 sa=0 sb=0 sd=0 m=1
D00409 (inh_lSup inh_hsupanalog) sky130_fd_pr__diode_pd2nw_05v5 area=1 perim=4 mult=1 m=1
M00410 (N00145 N00143 inh_hsupanalog inh_bulkpanalog) sky130_fd_pr__pfet_g5v0d10v5 w=2.3 l=1 nf=1 mult=1 ad=0.667 as=0.667 pd=5.18 ps=5.18 sa=0 sb=0 sd=0 m=1
M00411 (N00145 N00143 inh_lSup inh_lSup) sky130_fd_pr__nfet_g5v0d10v5 w=0.5 l=1 nf=1 mult=1 ad=0.145 as=0.145 pd=1.58 ps=1.58 sa=0 sb=0 sd=0 m=1
D00412 (inh_lSup inh_hsupanalog) sky130_fd_pr__diode_pd2nw_05v5 area=1 perim=4 mult=1 m=1
M00413 (N00107 N00105 inh_hsupanalog inh_bulkpanalog) sky130_fd_pr__pfet_g5v0d10v5 w=2.3 l=1 nf=1 mult=1 ad=0.667 as=0.667 pd=5.18 ps=5.18 sa=0 sb=0 sd=0 m=1
M00414 (N00107 N00105 inh_lSup inh_lSup) sky130_fd_pr__nfet_g5v0d10v5 w=0.5 l=1 nf=1 mult=1 ad=0.145 as=0.145 pd=1.58 ps=1.58 sa=0 sb=0 sd=0 m=1
D00415 (inh_lSup inh_hsupanalog) sky130_fd_pr__diode_pd2nw_05v5 area=1 perim=4 mult=1 m=1
M00416 (N00143 N00145 inh_hsupanalog inh_bulkpanalog) sky130_fd_pr__pfet_g5v0d10v5 w=2.3 l=1 nf=1 mult=1 ad=0.667 as=0.667 pd=5.18 ps=5.18 sa=0 sb=0 sd=0 m=1
M00417 (N00143 N00145 inh_lSup inh_lSup) sky130_fd_pr__nfet_g5v0d10v5 w=0.5 l=1 nf=1 mult=1 ad=0.145 as=0.145 pd=1.58 ps=1.58 sa=0 sb=0 sd=0 m=1
D00418 (inh_lSup inh_hsupanalog) sky130_fd_pr__diode_pd2nw_05v5 area=1 perim=4 mult=1 m=1
M00419 (N00105 N00107 inh_hsupanalog inh_bulkpanalog) sky130_fd_pr__pfet_g5v0d10v5 w=2.3 l=1 nf=1 mult=1 ad=0.667 as=0.667 pd=5.18 ps=5.18 sa=0 sb=0 sd=0 m=1
M00420 (N00105 N00107 inh_lSup inh_lSup) sky130_fd_pr__nfet_g5v0d10v5 w=0.5 l=1 nf=1 mult=1 ad=0.145 as=0.145 pd=1.58 ps=1.58 sa=0 sb=0 sd=0 m=1
D00421 (inh_lSup inh_hsupanalog) sky130_fd_pr__diode_pd2nw_05v5 area=1 perim=4 mult=1 m=1
C00422 (N00113 N00115) capacitor c=500f
C00423 (N00113 N00115) capacitor c=500f
R00424 (N00038 N00049) resistor r=242.42K
R00425 (N00049 inh_lSup) resistor r=1.09MEG
R00426 (inh_hsupanalog N00038) resistor r=1.167MEG
C00427 (N00067 N00064) capacitor c=20p
M00428 (N00104 N00055 inh_lSup inh_bulkn) sky130_fd_pr__nfet_g5v0d10v5 w=0.5 l=0.5 nf=1 mult=1 ad=0.145 as=0.145 pd=1.58 ps=1.58 sa=0 sb=0 sd=0 m=1
M00429 (N00104 N00055 vref_ai vref_ai) sky130_fd_pr__pfet_g5v0d10v5 w=2.5 l=0.5 nf=1 mult=1 ad=0.725 as=0.725 pd=5.58 ps=5.58 sa=0 sb=0 sd=0 m=1
ends infineon_ldo_transistor
