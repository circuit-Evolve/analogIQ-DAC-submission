// analogiq 0.1.0 testbench - generated, do not edit
// task ldo_ifx_task_001  topology ldo_ifx
// recipe ifx_ldo_sequence_v1 v1  condition tt_T27_S1p00 (models tt, 27 C, supply 3.3 V)
// request ldo_ifx_task_001__plan  candidate b9319a3b22d0f867
// execution profile search_full
simulator lang=spectre
global 0
include "<PDK_ROOT>/sky130_cds/spectre/libs.tech/combined/sky130.lib.spice" section=tt
include "dut.scs"

parameters vin=3.3 cout=1e-12
// Supplies (charged to the DUT power metrics).
VIN (vin 0) vsource type=pwl wave=[0.0 3.3 6.202e-05 3.3 6.202100000000001e-05 3.6959999999999997 6.702e-05 3.6959999999999997 6.702100000000001e-05 3.3 6.703e-05 3.3 6.7031e-05 2.904 7.203e-05 2.904 7.2031e-05 3.3 0.00013204 3.3 0.00013204099999999998 3.564 0.00017203999999999999 3.564 0.00017204099999999997 3.3 0.00017204999999999998 3.3 0.00017205099999999997 3.0359999999999996 0.00021204999999999998 3.0359999999999996 0.00021205099999999997 3.3]
// External bias (topology external_bias; reported separately as bias power).
VB_inh_lSup (b_inh_lSup 0) vsource dc=0.0
VB_inh_bulkn (b_inh_bulkn 0) vsource dc=0.0
VB_inh_bulkpanalog (vin b_inh_bulkpanalog) vsource dc=0.0
VB_clk_i (b_clk_i 0) vsource type=pwl wave=[0.0 0.0 3e-06 0.0 3.001e-06 3.3 4.25e-06 3.3 4.251e-06 0.0 5.5e-06 0.0 5.5009999999999995e-06 3.3 6.75e-06 3.3 6.750999999999999e-06 0.0 8e-06 0.0 8.001e-06 3.3 9.25e-06 3.3 9.251e-06 0.0 1.05e-05 0.0 1.0501e-05 3.3 1.175e-05 3.3 1.1751e-05 0.0 1.3e-05 0.0 1.3001e-05 3.3 1.4249999999999999e-05 3.3 1.4251e-05 0.0 1.55e-05 0.0 1.5501e-05 3.3 1.675e-05 3.3 1.6751e-05 0.0 1.8e-05 0.0 1.8001e-05 3.3 1.925e-05 3.3 1.9251e-05 0.0 2.05e-05 0.0 2.0501e-05 3.3 2.175e-05 3.3 2.1751e-05 0.0 2.3e-05 0.0 2.3001e-05 3.3 2.425e-05 3.3 2.4251e-05 0.0 2.55e-05 0.0 2.5501e-05 3.3 2.675e-05 3.3 2.6751e-05 0.0 2.8e-05 0.0 2.8001e-05 3.3 2.925e-05 3.3 2.9250999999999998e-05 0.0 3.05e-05 0.0 3.0500999999999998e-05 3.3 3.175e-05 3.3 3.1751e-05 0.0 3.3e-05 0.0 3.3001000000000005e-05 3.3 3.4250000000000006e-05 3.3 3.425100000000001e-05 0.0 3.550000000000001e-05 0.0 3.550100000000001e-05 3.3 3.675000000000001e-05 3.3 3.6751000000000015e-05 0.0 3.8000000000000016e-05 0.0 3.800100000000002e-05 3.3 3.925000000000002e-05 3.3 3.925100000000002e-05 0.0 4.050000000000002e-05 0.0 4.0501000000000024e-05 3.3 4.1750000000000025e-05 3.3 4.175100000000003e-05 0.0 4.300000000000003e-05 0.0 4.300100000000003e-05 3.3 4.425000000000003e-05 3.3 4.4251000000000034e-05 0.0 4.5500000000000035e-05 0.0 4.550100000000004e-05 3.3 4.675000000000004e-05 3.3 4.675100000000004e-05 0.0 4.800000000000004e-05 0.0 4.8001000000000044e-05 3.3 4.9250000000000045e-05 3.3 4.925100000000005e-05 0.0 5.050000000000005e-05 0.0 5.050100000000005e-05 3.3 5.175000000000005e-05 3.3 5.1751000000000054e-05 0.0 5.3000000000000055e-05 0.0 5.300100000000006e-05 3.3 5.425000000000006e-05 3.3 5.425100000000006e-05 0.0 5.550000000000006e-05 0.0 5.5501000000000064e-05 3.3 5.6750000000000065e-05 3.3 5.675100000000007e-05 0.0 5.800000000000007e-05 0.0 5.800100000000007e-05 3.3 5.925000000000007e-05 3.3 5.9251000000000074e-05 0.0 6.0500000000000075e-05 0.0 6.050100000000008e-05 3.3 6.175000000000008e-05 3.3 6.175100000000008e-05 0.0 6.202e-05 0.0 6.202100000000001e-05 0.0 6.300000000000008e-05 0.0 6.300100000000008e-05 3.6959999999999997 6.425000000000008e-05 3.6959999999999997 6.425100000000009e-05 0.0 6.550000000000009e-05 0.0 6.550100000000009e-05 3.6959999999999997 6.675000000000009e-05 3.6959999999999997 6.67510000000001e-05 0.0 6.702e-05 0.0 6.702100000000001e-05 0.0 6.703e-05 0.0 6.7031e-05 0.0 6.80000000000001e-05 0.0 6.80010000000001e-05 2.904 6.92500000000001e-05 2.904 6.92510000000001e-05 0.0 7.05000000000001e-05 0.0 7.05010000000001e-05 2.904 7.17500000000001e-05 2.904 7.17510000000001e-05 0.0 7.203e-05 0.0 7.2031e-05 0.0 7.300000000000011e-05 0.0 7.300100000000011e-05 3.3 7.425000000000011e-05 3.3 7.425100000000011e-05 0.0 7.550000000000011e-05 0.0 7.550100000000012e-05 3.3 7.675000000000012e-05 3.3 7.675100000000012e-05 0.0 7.800000000000012e-05 0.0 7.800100000000012e-05 3.3 7.925000000000012e-05 3.3 7.925100000000013e-05 0.0 8.050000000000013e-05 0.0 8.050100000000013e-05 3.3 8.175000000000013e-05 3.3 8.175100000000013e-05 0.0 8.300000000000013e-05 0.0 8.300100000000014e-05 3.3 8.425000000000014e-05 3.3 8.425100000000014e-05 0.0 8.550000000000014e-05 0.0 8.550100000000014e-05 3.3 8.675000000000014e-05 3.3 8.675100000000015e-05 0.0 8.800000000000015e-05 0.0 8.800100000000015e-05 3.3 8.925000000000015e-05 3.3 8.925100000000015e-05 0.0 9.050000000000015e-05 0.0 9.050100000000016e-05 3.3 9.175000000000016e-05 3.3 9.175100000000016e-05 0.0 9.300000000000016e-05 0.0 9.300100000000016e-05 3.3 9.425000000000016e-05 3.3 9.425100000000017e-05 0.0 9.550000000000017e-05 0.0 9.550100000000017e-05 3.3 9.675000000000017e-05 3.3 9.675100000000017e-05 0.0 9.800000000000017e-05 0.0 9.800100000000018e-05 3.3 9.925000000000018e-05 3.3 9.925100000000018e-05 0.0 0.00010050000000000018 0.0 0.00010050100000000018 3.3 0.00010175000000000018 3.3 0.00010175100000000019 0.0 0.00010300000000000019 0.0 0.00010300100000000019 3.3 0.00010425000000000019 3.3 0.00010425100000000019 0.0 0.00010550000000000019 0.0 0.0001055010000000002 3.3 0.0001067500000000002 3.3 0.0001067510000000002 0.0 0.0001080000000000002 0.0 0.0001080010000000002 3.3 0.0001092500000000002 3.3 0.0001092510000000002 0.0 0.0001105000000000002 0.0 0.00011050100000000021 3.3 0.00011175000000000021 3.3 0.00011175100000000021 0.0 0.00011300000000000021 0.0 0.00011300100000000021 3.3 0.00011425000000000022 3.3 0.00011425100000000022 0.0 0.00011550000000000022 0.0 0.00011550100000000022 3.3 0.00011675000000000022 3.3 0.00011675100000000022 0.0 0.00011800000000000023 0.0 0.00011800100000000023 3.3 0.00011925000000000023 3.3 0.00011925100000000023 0.0 0.00012050000000000023 0.0 0.00012050100000000023 3.3 0.00012175000000000024 3.3 0.00012175100000000024 0.0 0.00012300000000000023 0.0 0.00012300100000000021 3.3 0.00012425000000000023 3.3 0.00012425100000000022 0.0 0.00012550000000000023 0.0 0.00012550100000000022 3.3 0.00012675000000000023 3.3 0.00012675100000000022 0.0 0.00012800000000000024 0.0 0.00012800100000000023 3.3 0.00012925000000000024 3.3 0.00012925100000000023 0.0 0.00013050000000000024 0.0 0.00013050100000000023 3.3 0.00013175000000000025 3.3 0.00013175100000000024 0.0 0.00013204 0.0 0.00013204099999999998 0.0 0.00013300000000000025 0.0 0.00013300100000000024 3.564 0.00013425000000000025 3.564 0.00013425100000000024 0.0 0.00013550000000000026 0.0 0.00013550100000000025 3.564 0.00013675000000000026 3.564 0.00013675100000000025 0.0 0.00013800000000000026 0.0 0.00013800100000000025 3.564 0.00013925000000000027 3.564 0.00013925100000000026 0.0 0.00014050000000000027 0.0 0.00014050100000000026 3.564 0.00014175000000000027 3.564 0.00014175100000000026 0.0 0.00014300000000000028 0.0 0.00014300100000000027 3.564 0.00014425000000000028 3.564 0.00014425100000000027 0.0 0.00014550000000000028 0.0 0.00014550100000000027 3.564 0.0001467500000000003 3.564 0.00014675100000000028 0.0 0.0001480000000000003 0.0 0.00014800100000000028 3.564 0.0001492500000000003 3.564 0.00014925100000000028 0.0 0.0001505000000000003 0.0 0.00015050100000000029 3.564 0.0001517500000000003 3.564 0.0001517510000000003 0.0 0.0001530000000000003 0.0 0.0001530010000000003 3.564 0.0001542500000000003 3.564 0.0001542510000000003 0.0 0.0001555000000000003 0.0 0.0001555010000000003 3.564 0.00015675000000000031 3.564 0.0001567510000000003 0.0 0.00015800000000000032 0.0 0.0001580010000000003 3.564 0.00015925000000000032 3.564 0.0001592510000000003 0.0 0.00016050000000000032 0.0 0.0001605010000000003 3.564 0.00016175000000000033 3.564 0.00016175100000000032 0.0 0.00016300000000000033 0.0 0.00016300100000000032 3.564 0.00016425000000000033 3.564 0.00016425100000000032 0.0 0.00016550000000000034 0.0 0.00016550100000000033 3.564 0.00016675000000000034 3.564 0.00016675100000000033 0.0 0.00016800000000000034 0.0 0.00016800100000000033 3.564 0.00016925000000000035 3.564 0.00016925100000000033 0.0 0.00017050000000000035 0.0 0.00017050100000000034 3.564 0.00017175000000000035 3.564 0.00017175100000000034 0.0 0.00017203999999999999 0.0 0.00017204099999999997 0.0 0.00017204999999999998 0.0 0.00017205099999999997 0.0 0.00017300000000000036 0.0 0.00017300100000000034 3.0359999999999996 0.00017425000000000036 3.0359999999999996 0.00017425100000000035 0.0 0.00017550000000000036 0.0 0.00017550100000000035 3.0359999999999996 0.00017675000000000037 3.0359999999999996 0.00017675100000000035 0.0 0.00017800000000000037 0.0 0.00017800100000000036 3.0359999999999996 0.00017925000000000037 3.0359999999999996 0.00017925100000000036 0.0 0.00018050000000000038 0.0 0.00018050100000000036 3.0359999999999996 0.00018175000000000038 3.0359999999999996 0.00018175100000000037 0.0 0.00018300000000000038 0.0 0.00018300100000000037 3.0359999999999996 0.00018425000000000039 3.0359999999999996 0.00018425100000000037 0.0 0.0001855000000000004 0.0 0.00018550100000000038 3.0359999999999996 0.0001867500000000004 3.0359999999999996 0.00018675100000000038 0.0 0.0001880000000000004 0.0 0.00018800100000000038 3.0359999999999996 0.0001892500000000004 3.0359999999999996 0.0001892510000000004 0.0 0.0001905000000000004 0.0 0.0001905010000000004 3.0359999999999996 0.0001917500000000004 3.0359999999999996 0.0001917510000000004 0.0 0.0001930000000000004 0.0 0.0001930010000000004 3.0359999999999996 0.0001942500000000004 3.0359999999999996 0.0001942510000000004 0.0 0.00019550000000000042 0.0 0.0001955010000000004 3.0359999999999996 0.00019675000000000042 3.0359999999999996 0.0001967510000000004 0.0 0.00019800000000000042 0.0 0.0001980010000000004 3.0359999999999996 0.00019925000000000043 3.0359999999999996 0.00019925100000000041 0.0 0.00020050000000000043 0.0 0.00020050100000000042 3.0359999999999996 0.00020175000000000043 3.0359999999999996 0.00020175100000000042 0.0 0.00020300000000000043 0.0 0.00020300100000000042 3.0359999999999996 0.00020425000000000044 3.0359999999999996 0.00020425100000000043 0.0 0.00020550000000000044 0.0 0.00020550100000000043 3.0359999999999996 0.00020675000000000044 3.0359999999999996 0.00020675100000000043 0.0 0.00020800000000000045 0.0 0.00020800100000000044 3.0359999999999996 0.00020925000000000045 3.0359999999999996 0.00020925100000000044 0.0 0.00021050000000000045 0.0 0.00021050100000000044 3.0359999999999996 0.00021175000000000046 3.0359999999999996 0.00021175100000000045 0.0 0.00021204999999999998 0.0 0.00021205099999999997 0.0 0.00021300000000000046 0.0 0.00021300100000000045 3.3 0.00021425000000000046 3.3 0.00021425100000000045 0.0 0.00021550000000000047 0.0 0.00021550100000000046 3.3 0.00021675000000000047 3.3 0.00021675100000000046 0.0 0.00021800000000000047 0.0 0.00021800100000000046 3.3 0.00021925000000000048 3.3 0.00021925100000000047 0.0 0.00022050000000000048 0.0 0.00022050100000000047 3.3 0.00022175000000000048 3.3 0.00022175100000000047 0.0 0.0002230000000000005 0.0 0.00022300100000000048 3.3 0.0002242500000000005 3.3 0.00022425100000000048 0.0 0.0002255000000000005 0.0 0.00022550100000000048 3.3 0.0002267500000000005 3.3 0.00022675100000000049 0.0 0.0002280000000000005 0.0 0.0002280010000000005 3.3 0.0002292500000000005 3.3 0.0002292510000000005 0.0 0.0002305000000000005 0.0 0.0002305010000000005 3.3 0.0002317500000000005 3.3 0.0002317510000000005 0.0 0.00023300000000000051 0.0 0.0002330010000000005 3.3 0.00023425000000000052 3.3 0.0002342510000000005 0.0 0.00023550000000000052 0.0 0.0002355010000000005 3.3 0.00023675000000000052 3.3 0.0002367510000000005 0.0 0.00023800000000000053 0.0 0.00023800100000000052 3.3 0.00023925000000000053 3.3 0.00023925100000000052 0.0 0.00024050000000000053 0.0 0.00024050100000000052 3.3 0.00024175000000000054 3.3 0.00024175100000000053 0.0 0.00024300000000000054 0.0 0.00024300100000000053 3.3 0.00024425000000000054 3.3 0.00024425100000000056 0.0 0.00024550000000000055 0.0 0.00024550100000000056 3.3 0.00024675000000000055 3.3 0.00024675100000000057 0.0 0.00024800000000000055 0.0 0.00024800100000000057 3.3 0.00024925000000000056 3.3 0.00024925100000000057 0.0 0.00025050000000000056 0.0 0.0002505010000000006 3.3 0.00025175000000000056 3.3 0.0002517510000000006 0.0 0.00025300000000000057 0.0 0.0002530010000000006 3.3 0.00025425000000000057 3.3 0.0002542510000000006 0.0 0.00025550000000000057 0.0 0.0002555010000000006 3.3 0.0002567500000000006 3.3 0.0002567510000000006 0.0 0.0002580000000000006 0.0 0.0002580010000000006 3.3 0.0002592500000000006 3.3 0.0002592510000000006 0.0 0.0002605000000000006 0.0 0.0002605010000000006 3.3 0.0002617500000000006 3.3 0.0002617510000000006 0.0 0.0002630000000000006 0.0 0.0002630010000000006 3.3 0.0002642500000000006 3.3 0.0002642510000000006 0.0 0.0002655000000000006 0.0 0.0002655010000000006 3.3 0.0002667500000000006 3.3 0.0002667510000000006 0.0 0.0002680000000000006 0.0 0.0002680010000000006 3.3 0.0002692500000000006 3.3 0.0002692510000000006 0.0 0.0002705000000000006 0.0 0.00027050100000000063 3.3 0.0002717500000000006 3.3 0.00027175100000000063 0.0 0.0002730000000000006 0.0 0.00027300100000000063 3.3 0.0002742500000000006 3.3 0.00027425100000000064 0.0 0.0002755000000000006 0.0 0.00027550100000000064 3.3 0.00027675000000000063 3.3 0.00027675100000000064 0.0 0.00027800000000000063 0.0 0.00027800100000000065 3.3 0.00027925000000000063 3.3 0.00027925100000000065 0.0 0.00028050000000000064 0.0 0.00028050100000000065 3.3 0.00028175000000000064 3.3 0.00028175100000000066 0.0 0.00028300000000000064 0.0 0.00028300100000000066 3.3 0.00028425000000000065 3.3 0.00028425100000000066 0.0 0.00028550000000000065 0.0 0.00028550100000000067 3.3 0.00028675000000000065 3.3 0.00028675100000000067 0.0 0.00028800000000000066 0.0 0.0002880010000000007 3.3 0.00028925000000000066 3.3 0.0002892510000000007 0.0 0.00029050000000000066 0.0 0.0002905010000000007 3.3 0.00029175000000000067 3.3 0.0002917510000000007 0.0 0.00029300000000000067 0.0 0.0002930010000000007 3.3 0.0002942500000000007 3.3 0.0002942510000000007 0.0 0.0002955000000000007 0.0 0.0002955010000000007 3.3 0.0002967500000000007 3.3 0.0002967510000000007 0.0 0.0002980000000000007 0.0 0.0002980010000000007 3.3 0.0002992500000000007 3.3 0.0002992510000000007 0.0 0.0003005000000000007 0.0 0.0003005010000000007 3.3 0.0003017500000000007 3.3 0.0003017510000000007 0.0 0.0003030000000000007 0.0 0.0003030010000000007 3.3 0.0003042500000000007 3.3 0.0003042510000000007 0.0 0.0003055000000000007 0.0 0.0003055010000000007 3.3 0.0003067500000000007 3.3 0.0003067510000000007 0.0 0.0003080000000000007 0.0 0.0003080010000000007 3.3 0.0003092500000000007 3.3 0.00030925100000000073 0.0 0.0003105000000000007 0.0 0.00031050100000000073 3.3 0.0003117500000000007 3.3 0.00031175100000000074 0.0 0.0003130000000000007 0.0 0.00031300100000000074 3.3 0.0003142500000000007 3.3 0.00031425100000000074 0.0 0.00031550000000000073 0.0 0.00031550100000000075 3.3 0.00031675000000000073 3.3 0.00031675100000000075 0.0 0.00031800000000000074 0.0 0.00031800100000000075 3.3 0.00031925000000000074 3.3 0.00031925100000000076 0.0 0.00032050000000000074 0.0 0.00032050100000000076 3.3 0.00032175000000000075 3.3 0.00032175100000000076 0.0 0.00032300000000000075 0.0 0.00032300100000000077 3.3 0.00032425000000000075 3.3 0.00032425100000000077 0.0 0.00032550000000000076 0.0 0.00032550100000000077 3.3 0.00032675000000000076 3.3 0.0003267510000000008 0.0 0.00032800000000000076 0.0 0.0003280010000000008 3.3 0.00032925000000000077 3.3 0.0003292510000000008 0.0 0.00033050000000000077 0.0 0.0003305010000000008 3.3 0.00033175000000000077 3.3 0.0003317510000000008 0.0 0.0003330000000000008 0.0 0.0003330010000000008 3.3 0.0003342500000000008 3.3 0.0003342510000000008 0.0 0.0003355000000000008 0.0 0.0003355010000000008 3.3 0.0003367500000000008 3.3 0.0003367510000000008 0.0 0.0003380000000000008 0.0 0.0003380010000000008 3.3 0.0003392500000000008 3.3 0.0003392510000000008 0.0 0.0003405000000000008 0.0 0.0003405010000000008 3.3 0.0003417500000000008 3.3 0.0003417510000000008 0.0 0.0003430000000000008 0.0 0.0003430010000000008 3.3 0.0003442500000000008 3.3 0.0003442510000000008 0.0 0.0003455000000000008 0.0 0.0003455010000000008 3.3 0.0003467500000000008 3.3 0.00034675100000000083 0.0 0.0003480000000000008 0.0 0.00034800100000000083 3.3 0.0003492500000000008 3.3 0.00034925100000000083 0.0 0.0003505000000000008 0.0 0.00035050100000000084 3.3 0.0003517500000000008 3.3 0.00035175100000000084 0.0 0.00035300000000000083 0.0 0.00035300100000000084 3.3 0.00035425000000000083 3.3 0.00035425100000000085 0.0 0.00035550000000000083 0.0 0.00035550100000000085 3.3 0.00035675000000000084 3.3 0.00035675100000000085 0.0 0.00035800000000000084 0.0 0.00035800100000000086 3.3 0.00035925000000000084 3.3 0.00035925100000000086 0.0 0.00036050000000000085 0.0 0.00036050100000000086 3.3 0.00036175000000000085 3.3 0.00036175100000000087 0.0 0.00036300000000000085 0.0 0.00036300100000000087 3.3 0.00036425000000000086 3.3 0.0003642510000000009 0.0 0.00036550000000000086 0.0 0.0003655010000000009 3.3 0.00036675000000000086 3.3 0.0003667510000000009 0.0 0.00036800000000000087 0.0 0.0003680010000000009 3.3 0.00036925000000000087 3.3 0.0003692510000000009 0.0 0.0003705000000000009 0.0 0.0003705010000000009 3.3 0.0003717500000000009 3.3 0.0003717510000000009 0.0 0.0003730000000000009 0.0 0.0003730010000000009 3.3 0.0003742500000000009 3.3 0.0003742510000000009 0.0 0.0003755000000000009 0.0 0.0003755010000000009 3.3 0.0003767500000000009 3.3 0.0003767510000000009 0.0 0.0003780000000000009 0.0 0.0003780010000000009 3.3 0.0003792500000000009 3.3 0.0003792510000000009 0.0 0.0003805000000000009 0.0 0.0003805010000000009 3.3 0.0003817500000000009 3.3 0.0003817510000000009 0.0 0.0003830000000000009 0.0 0.0003830010000000009 3.3 0.0003842500000000009 3.3 0.0003842510000000009 0.0 0.0003855000000000009 0.0 0.00038550100000000093 3.3 0.0003867500000000009 3.3 0.00038675100000000093 0.0 0.0003880000000000009 0.0 0.00038800100000000094 3.3 0.0003892500000000009 3.3 0.00038925100000000094 0.0 0.0003905000000000009 0.0 0.00039050100000000094 3.3 0.00039175000000000093 3.3 0.00039175100000000095 0.0 0.00039300000000000093 0.0 0.00039300100000000095 3.3 0.00039425000000000094 3.3 0.00039425100000000095 0.0 0.00039550000000000094 0.0 0.00039550100000000096 3.3 0.00039675000000000094 3.3 0.00039675100000000096 0.0 0.00039800000000000095 0.0 0.00039800100000000096 3.3 0.00039925000000000095 3.3 0.00039925100000000097 0.0 0.00040050000000000095 0.0 0.00040050100000000097 3.3 0.00040175000000000096 3.3 0.00040175100000000097 0.0 0.00040300000000000096 0.0 0.000403001000000001 3.3 0.00040425000000000096 3.3 0.000404251000000001 0.0 0.00040550000000000097 0.0 0.000405501000000001 3.3 0.00040675000000000097 3.3 0.000406751000000001 0.0 0.00040800000000000097 0.0 0.000408001000000001 3.3 0.000409250000000001 3.3 0.000409251000000001 0.0 0.000410500000000001 0.0 0.000410501000000001 3.3 0.000411750000000001 3.3 0.000411751000000001 0.0 0.000413000000000001 0.0 0.000413001000000001 3.3 0.000414250000000001 3.3 0.000414251000000001 0.0 0.000415500000000001 0.0 0.000415501000000001 3.3 0.000416750000000001 3.3 0.000416751000000001 0.0 0.000418000000000001 0.0 0.000418001000000001 3.3 0.000419250000000001 3.3 0.000419251000000001 0.0 0.000420500000000001 0.0 0.000420501000000001 3.3 0.000421750000000001 3.3 0.000421751000000001 0.0 0.000423000000000001 0.0 0.00042300100000000103 3.3 0.000424250000000001 3.3 0.00042425100000000103 0.0 0.000425500000000001 0.0 0.00042550100000000103 3.3 0.000426750000000001 3.3 0.00042675100000000104 0.0 0.000428000000000001 0.0 0.00042800100000000104 3.3 0.00042925000000000103 3.3 0.00042925100000000104 0.0 0.00043050000000000103 0.0 0.00043050100000000105 3.3 0.00043175000000000103 3.3 0.00043175100000000105 0.0 0.00043300000000000104 0.0 0.00043300100000000105 3.3 0.00043425000000000104 3.3 0.00043425100000000106 0.0 0.00043550000000000104 0.0 0.00043550100000000106 3.3 0.00043675000000000105 3.3 0.00043675100000000106 0.0 0.00043800000000000105 0.0 0.00043800100000000107 3.3 0.00043925000000000105 3.3 0.00043925100000000107 0.0 0.00044050000000000106 0.0 0.0004405010000000011 3.3 0.00044175000000000106 3.3 0.0004417510000000011 0.0 0.00044300000000000106 0.0 0.0004430010000000011 3.3 0.00044425000000000107 3.3 0.0004442510000000011 0.0 0.00044550000000000107 0.0 0.0004455010000000011 3.3 0.0004467500000000011 3.3 0.0004467510000000011 0.0 0.0004480000000000011 0.0 0.0004480010000000011 3.3 0.0004492500000000011 3.3 0.0004492510000000011 0.0 0.0004505000000000011 0.0 0.0004505010000000011 3.3 0.0004517500000000011 3.3 0.0004517510000000011 0.0 0.0004530000000000011 0.0 0.0004530010000000011 3.3 0.0004542500000000011 3.3 0.0004542510000000011 0.0 0.0004555000000000011 0.0 0.0004555010000000011 3.3 0.0004567500000000011 3.3 0.0004567510000000011 0.0 0.0004580000000000011 0.0 0.0004580010000000011 3.3 0.0004592500000000011 3.3 0.0004592510000000011 0.0 0.0004605000000000011 0.0 0.0004605010000000011 3.3 0.0004617500000000011 3.3 0.00046175100000000113 0.0 0.0004630000000000011 0.0 0.00046300100000000113 3.3 0.0004642500000000011 3.3 0.00046425100000000114 0.0 0.0004655000000000011 0.0 0.00046550100000000114 3.3 0.0004667500000000011 3.3 0.00046675100000000114 0.0 0.00046800000000000113 0.0 0.00046800100000000115 3.3 0.00046925000000000113 3.3 0.00046925100000000115 0.0 0.00047050000000000114 0.0 0.00047050100000000115 3.3 0.00047175000000000114 3.3 0.00047175100000000116 0.0 0.00047300000000000114 0.0 0.00047300100000000116 3.3 0.00047425000000000115 3.3 0.00047425100000000116 0.0 0.00047550000000000115 0.0 0.00047550100000000117 3.3 0.00047675000000000115 3.3 0.00047675100000000117 0.0 0.00047800000000000116 0.0 0.00047800100000000117 3.3 0.00047925000000000116 3.3 0.0004792510000000012 0.0 0.00048050000000000116 0.0 0.0004805010000000012 3.3 0.00048175000000000117 3.3 0.0004817510000000012 0.0 0.00048300000000000117 0.0 0.0004830010000000012 3.3 0.00048425000000000117 3.3 0.0004842510000000012 0.0 0.0004855000000000012 0.0 0.0004855010000000012 3.3 0.0004867500000000012 3.3 0.0004867510000000012 0.0 0.0004880000000000012 0.0 0.0004880010000000012 3.3 0.0004892500000000012 3.3 0.0004892510000000012 0.0 0.0004905000000000011 0.0 0.0004905010000000012 3.3 0.0004917500000000011 3.3 0.0004917510000000011 0.0 0.000493000000000001 0.0 0.000493001000000001 3.3 0.000494250000000001 3.3 0.000494251000000001 0.0 0.0004955000000000009 0.0 0.000495501000000001 3.3 0.0004967500000000009 3.3 0.0004967510000000009 0.0 0.0004980000000000008 0.0 0.0004980010000000008 3.3 0.0004992500000000008 3.3 0.0004992510000000008 0.0 0.0005005000000000007 0.0 0.0005005010000000007 3.3 0.0005017500000000007 3.3 0.0005017510000000007 0.0 0.0005030000000000006 0.0 0.0005030010000000006 3.3 0.0005042500000000006 3.3 0.0005042510000000006 0.0 0.0005055000000000005 0.0 0.0005055010000000005 3.3 0.0005067500000000005 3.3 0.0005067510000000005 0.0 0.0005080000000000004 0.0 0.0005080010000000004 3.3 0.0005092500000000004 3.3 0.0005092510000000004 0.0 0.0005105000000000003 0.0 0.0005105010000000003 3.3 0.0005117500000000003 3.3 0.0005117510000000003 0.0 0.0005130000000000002 0.0 0.0005130010000000002 3.3 0.0005142500000000002 3.3 0.0005142510000000002 0.0 0.0005155000000000001 0.0 0.0005155010000000001 3.3 0.0005167500000000001 3.3 0.0005167510000000001 0.0 0.000518 0.0 0.000518001 3.3 0.00051925 3.3 0.000519251 0.0]
VB_disable_i (b_disable_i 0) vsource type=pwl wave=[0.0 3.3 2.01e-06 3.3 2.011e-06 0.0 6.202e-05 0.0 6.202100000000001e-05 0.0 6.702e-05 0.0 6.702100000000001e-05 0.0 6.703e-05 0.0 6.7031e-05 0.0 7.203e-05 0.0 7.2031e-05 0.0 0.00013204 0.0 0.00013204099999999998 0.0 0.00017203999999999999 0.0 0.00017204099999999997 0.0 0.00017204999999999998 0.0 0.00017205099999999997 0.0 0.00021204999999999998 0.0 0.00021205099999999997 0.0 0.00025205999999999997 0.0 0.000252061 3.3 0.00025507 3.3 0.000255071 0.0]
IB_ibp_1u_ai (vin b_ibp_1u_ai) isource dc=1e-06

// ldo_checker.va stimulus: supply offsets x1.32, clock / disable levels follow the supply.
VREFS (vref 0) vsource type=pwl wave=[0.0 1.2 0.00030508 1.2 0.000305081 1.25 0.00034508000000000005 1.25 0.00034508100000000007 1.2 0.00034509000000000005 1.2 0.00034509100000000006 1.15 0.0003850900000000001 1.15 0.0003850910000000001 1.2]
ILOAD (out 0) isource type=pwl wave=[0.0 0.0 0.00042510000000000014 0.0 0.00042510100000000016 0.005 0.0004651000000000002 0.005 0.0004651010000000002 0.0 0.0004651100000000002 0.0 0.0004651110000000002 -0.005 0.0005051100000000002 -0.005 0.0005051110000000003 0.0]
RLOAD (out 0) resistor r=75.0
COUT (out 0) capacitor c=cout
CFOV (open_overvoltage_o 0) capacitor c=5e-14
CFUV (open_undervoltage_o 0) capacitor c=5e-14

XDUT (b_clk_i b_disable_i b_ibp_1u_ai open_overvoltage_o open_undervoltage_o out vref b_inh_bulkn b_inh_bulkpanalog vin b_inh_lSup) ldo_ifx_dut C_INT={{C_INT}} C_MILLER={{C_MILLER}} C_SCF={{C_SCF}} L_CMP_DN={{L_CMP_DN}} L_CMP_DP={{L_CMP_DP}} L_CMP_IN={{L_CMP_IN}} L_CMP_LN={{L_CMP_LN}} L_CMP_MP={{L_CMP_MP}} L_CMP_ON={{L_CMP_ON}} L_CMP_OP={{L_CMP_OP}} L_FOL={{L_FOL}} L_OA_CS={{L_OA_CS}} L_OA_IB={{L_OA_IB}} L_OA_IN={{L_OA_IN}} L_OA_LD={{L_OA_LD}} L_OA_PRN={{L_OA_PRN}} L_OA_PRP={{L_OA_PRP}} L_OA_SCAS={{L_OA_SCAS}} L_OA_SNK={{L_OA_SNK}} L_OA_TCAS={{L_OA_TCAS}} L_OA_TSRC={{L_OA_TSRC}} L_OA_VB={{L_OA_VB}} L_PASS={{L_PASS}} L_RES={{L_RES}} M_CMP_DN={{M_CMP_DN}} M_CMP_DP={{M_CMP_DP}} M_CMP_LN={{M_CMP_LN}} M_CMP_ON={{M_CMP_ON}} M_CMP_OP={{M_CMP_OP}} M_OA_IB={{M_OA_IB}} M_OA_LD={{M_OA_LD}} M_OA_PRN={{M_OA_PRN}} M_OA_PRP={{M_OA_PRP}} M_OA_TCAS={{M_OA_TCAS}} M_OA_TSRC={{M_OA_TSRC}} M_OA_VB={{M_OA_VB}} M_RES={{M_RES}} N_FOL={{N_FOL}} N_OA_CS={{N_OA_CS}} N_OA_SNK={{N_OA_SNK}} N_PASS={{N_PASS}} R_CMP_TAIL={{R_CMP_TAIL}} R_FB_BOT={{R_FB_BOT}} R_FB_TOP={{R_FB_TOP}} R_UV_BOT={{R_UV_BOT}} R_UV_MID={{R_UV_MID}} R_UV_TOP={{R_UV_TOP}} W_CMP_DN={{W_CMP_DN}} W_CMP_DP={{W_CMP_DP}} W_CMP_IN={{W_CMP_IN}} W_CMP_LN={{W_CMP_LN}} W_CMP_MP={{W_CMP_MP}} W_CMP_ON={{W_CMP_ON}} W_CMP_OP={{W_CMP_OP}} W_FOL={{W_FOL}} W_OA_CS={{W_OA_CS}} W_OA_IB={{W_OA_IB}} W_OA_IN={{W_OA_IN}} W_OA_LD={{W_OA_LD}} W_OA_PRN={{W_OA_PRN}} W_OA_PRP={{W_OA_PRP}} W_OA_SCAS={{W_OA_SCAS}} W_OA_SNK={{W_OA_SNK}} W_OA_TCAS={{W_OA_TCAS}} W_OA_TSRC={{W_OA_TSRC}} W_OA_VB={{W_OA_VB}} W_PASS={{W_PASS}} W_RES={{W_RES}}
op_info info what=oppoint where=rawfile

opts options temp=27.0 tnom=27 reltol=0.001 save=selected
save VB_clk_i:p VB_disable_i:p VB_inh_bulkn:p VB_inh_bulkpanalog:p VB_inh_lSup:p VIN:p XDUT.N00038 XDUT.N00049 XDUT.N00055 XDUT.N00063 XDUT.N00064 XDUT.N00067 XDUT.N00069 open_overvoltage_o open_undervoltage_o out vin vref

op_tr info what=oppoint where=rawfile
tr1 tran stop=0.0005202200000000003 maxstep=1e-07 errpreset=liberal infoname=op_tr infotimes=[5.49e-05]
