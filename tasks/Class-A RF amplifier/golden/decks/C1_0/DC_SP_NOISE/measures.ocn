opened=errset(openResults("raw") t)
fp=outfile("scalars.tsv")
v=nil
when(opened && car(opened) v=errset(cross((10 * log10(((mag(getData("s21" ?result "sp"))**2) / (1 - (mag(getData("s11" ?result "sp"))**2))))) (ymax((10 * log10(((mag(getData("s21" ?result "sp"))**2) / (1 - (mag(getData("s11" ?result "sp"))**2)))))) - 3) 1 "falling") t))
if(v && numberp(car(v)) then fprintf(fp "1\t%.16g\n" car(v)) else fprintf(fp "1\tERROR\n"))
v=nil
when(opened && car(opened) v=errset(cross((10 * log10(((mag(getData("s21" ?result "sp"))**2) / (1 - (mag(getData("s11" ?result "sp"))**2))))) (ymax((10 * log10(((mag(getData("s21" ?result "sp"))**2) / (1 - (mag(getData("s11" ?result "sp"))**2)))))) - 3) 1 "rising") t))
if(v && numberp(car(v)) then fprintf(fp "2\t%.16g\n" car(v)) else fprintf(fp "2\tERROR\n"))
v=nil
when(opened && car(opened) v=errset(((cross((10 * log10(((mag(getData("s21" ?result "sp"))**2) / (1 - (mag(getData("s11" ?result "sp"))**2))))) (ymax((10 * log10(((mag(getData("s21" ?result "sp"))**2) / (1 - (mag(getData("s11" ?result "sp"))**2)))))) - 3) 1 "falling") - cross((10 * log10(((mag(getData("s21" ?result "sp"))**2) / (1 - (mag(getData("s11" ?result "sp"))**2))))) (ymax((10 * log10(((mag(getData("s21" ?result "sp"))**2) / (1 - (mag(getData("s11" ?result "sp"))**2)))))) - 3) 1 "rising")) / 1000000.0) t))
if(v && numberp(car(v)) then fprintf(fp "5\t%.16g\n" car(v)) else fprintf(fp "5\tERROR\n"))
v=nil
when(opened && car(opened) v=errset(value(db20(getData("s12" ?result "sp")) 4.33e+08) t))
if(v && numberp(car(v)) then fprintf(fp "6\t%.16g\n" car(v)) else fprintf(fp "6\tERROR\n"))
v=nil
when(opened && car(opened) v=errset(value(db20(getData("s21" ?result "sp")) 4.33e+08) t))
if(v && numberp(car(v)) then fprintf(fp "7\t%.16g\n" car(v)) else fprintf(fp "7\tERROR\n"))
v=nil
when(opened && car(opened) v=errset(value(db20(getData("s11" ?result "sp")) 4.33e+08) t))
if(v && numberp(car(v)) then fprintf(fp "8\t%.16g\n" car(v)) else fprintf(fp "8\tERROR\n"))
v=nil
when(opened && car(opened) v=errset(ymax(clip(mag(((getData("s11" ?result "sp") * getData("s22" ?result "sp")) - (getData("s12" ?result "sp") * getData("s21" ?result "sp")))) 1000000.0 1e+09)) t))
if(v && numberp(car(v)) then fprintf(fp "9\t%.16g\n" car(v)) else fprintf(fp "9\tERROR\n"))
v=nil
when(opened && car(opened) v=errset(value(mag(((getData("s11" ?result "sp") * getData("s22" ?result "sp")) - (getData("s12" ?result "sp") * getData("s21" ?result "sp")))) 4.33e+08) t))
if(v && numberp(car(v)) then fprintf(fp "10\t%.16g\n" car(v)) else fprintf(fp "10\tERROR\n"))
v=nil
when(opened && car(opened) v=errset(ymin(clip((((1 - (mag(getData("s11" ?result "sp"))**2) - (mag(getData("s22" ?result "sp"))**2)) + (mag(((getData("s11" ?result "sp") * getData("s22" ?result "sp")) - (getData("s12" ?result "sp") * getData("s21" ?result "sp"))))**2)) / (2 * mag((getData("s12" ?result "sp") * getData("s21" ?result "sp"))))) 1000000.0 1e+09)) t))
if(v && numberp(car(v)) then fprintf(fp "11\t%.16g\n" car(v)) else fprintf(fp "11\tERROR\n"))
v=nil
when(opened && car(opened) v=errset(value(getData("NF" ?result "noise") 4.33e+08) t))
if(v && numberp(car(v)) then fprintf(fp "12\t%.16g\n" car(v)) else fprintf(fp "12\tERROR\n"))
v=nil
when(opened && car(opened) v=errset(value((((1 - (mag(getData("s11" ?result "sp"))**2) - (mag(getData("s22" ?result "sp"))**2)) + (mag(((getData("s11" ?result "sp") * getData("s22" ?result "sp")) - (getData("s12" ?result "sp") * getData("s21" ?result "sp"))))**2)) / (2 * mag((getData("s12" ?result "sp") * getData("s21" ?result "sp"))))) 4.33e+08) t))
if(v && numberp(car(v)) then fprintf(fp "13\t%.16g\n" car(v)) else fprintf(fp "13\tERROR\n"))
v=nil
when(opened && car(opened) v=errset(value((10 * log10(((mag(getData("s21" ?result "sp"))**2) / (1 - (mag(getData("s11" ?result "sp"))**2))))) 4.33e+08) t))
if(v && numberp(car(v)) then fprintf(fp "14\t%.16g\n" car(v)) else fprintf(fp "14\tERROR\n"))
v=nil
when(opened && car(opened) v=errset((-1000 * 12.0 * getData("VDD:p" ?result "dcOp")) t))
if(v && numberp(car(v)) then fprintf(fp "15\t%.16g\n" car(v)) else fprintf(fp "15\tERROR\n"))
v=nil
when(opened && car(opened) v=errset((1000 * getData("DUT.L0:1" ?result "dcOp")) t))
if(v && numberp(car(v)) then fprintf(fp "16\t%.16g\n" car(v)) else fprintf(fp "16\tERROR\n"))
v=nil
when(opened && car(opened) v=errset((getData("DUT.COLLECTOR" ?result "dcOp") - getData("DUT.EMITTER" ?result "dcOp")) t))
if(v && numberp(car(v)) then fprintf(fp "17\t%.16g\n" car(v)) else fprintf(fp "17\tERROR\n"))
v=nil
when(opened && car(opened) v=errset(value(db20(getData("s22" ?result "sp")) 4.33e+08) t))
if(v && numberp(car(v)) then fprintf(fp "18\t%.16g\n" car(v)) else fprintf(fp "18\tERROR\n"))
close(fp)
exit()
