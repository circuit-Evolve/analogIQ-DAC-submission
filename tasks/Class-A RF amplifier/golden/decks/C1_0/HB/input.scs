// Design: test/pa1088_tb_hb_dac
simulator lang=spectre
global 0
parameters VCC=12 f0=4.33e+08 Pin_dBm=1
include "<PDK_ROOT>/gpdk090_v4.6/models/spectre/gpdk090_bipolar.scs" section=highperf_bjt_f

// test/pa1088_fig3_dac/schematic
include "dut.scs"

// test/pa1088_tb_hb_dac/schematic
VDD (VCC 0) vsource dc=VCC type=dc
PORT_IN (RF_IN 0) port r=50 num=1 type=sine freq=f0 dbm=Pin_dBm
PORT_OUT (RF_OUT 0) port r=50 x=0 num=2 dc=0 type=dc
DUT (RF_IN RF_OUT VCC 0) pa1088_fig3_dac
simulatorOptions options reltol=1e-05 temp=-40
sweephb sweep param=Pin_dBm start=-40 stop=20 lin=600 {
  hb hb fundfreqs=[f0] maxharms=[25] freqdivide=1
+ errpreset=conservative annotate=status

}

saveOptions options currents=all
