simulator lang=spectre
subckt pa1088_fig3_dac RF_IN RF_OUT VCC VSS
    Q0 (COLLECTOR BASE EMITTER) gpdk090_npn area=0.5 m=10
    L17 (OUT_MATCH RF_OUT) inductor l=5.112429612217947e-08
    L0 (COL_BIAS COLLECTOR) inductor l=7.083781493513158e-08
    L1 (BASE_BIAS BASE) inductor l=1.6186834702955393e-05
    L16 (RF_IN IN_MATCH) inductor l=3.891702802496527e-08
    C27 (EMITTER VSS) capacitor c=4.282527027400597e-10
    C25 (OUT_MATCH VSS) capacitor c=5.036170439364871e-12
    C2 (COLLECTOR OUT_MATCH) capacitor c=5.5735569604160245e-12
    C3 (COL_BIAS VSS) capacitor c=1.2367911333285738e-13
    C4 (VCC VSS) capacitor c=10p
    C6 (BASE_BIAS VSS) capacitor c=10p
    C5 (BASE_BIAS VSS) capacitor c=8.2p
    C1 (IN_MATCH BASE) capacitor c=3.0132646179627335e-10
    C24 (IN_MATCH VSS) capacitor c=2.9373012556686784e-12
    R14 (EMITTER VSS) resistor r=83.3392708795
    R5 (VCC COL_BIAS) resistor r=15
    R3 (BASE_BIAS VCC) resistor r=9733.79378832986
ends pa1088_fig3_dac
