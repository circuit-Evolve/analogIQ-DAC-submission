// Design: test/pa1088_tb_small_signal_dac
simulator lang=spectre
global 0
parameters VCC=12 f0=4.33e+08
include "<PDK_ROOT>/gpdk090_v4.6/models/spectre/gpdk090_bipolar.scs" section=highperf_bjt_s

// test/pa1088_fig3_dac/schematic
include "dut.scs"

// test/pa1088_tb_small_signal_dac/schematic
VDD (VCC 0) vsource dc=VCC type=dc
PORT_IN (RF_IN 0) port r=50 num=1 type=sine freq=f0 dbm=-40
PORT_OUT (RF_OUT 0) port r=50 num=2 dc=0 type=dc
DUT (RF_IN RF_OUT VCC 0) pa1088_fig3_dac
simulatorOptions options reltol=1e-05 temp=100
dcOp dc
noise noise values=[433M] oprobe=PORT_OUT iprobe=PORT_IN
sp sp ports=[PORT_IN PORT_OUT] start=1M stop=1G dec=300 donoise=no oprobe=PORT_OUT iprobe=PORT_IN
saveOptions options currents=all
