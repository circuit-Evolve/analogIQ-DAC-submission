// Generated by analogiq from dut_benchmark.scs (sha256 0d29685556da6437).
// Connectivity and device models are unchanged except for the listed transformations:
//   (none)
subckt pa1088_fig3_dac (RF_IN RF_OUT VCC VSS)
parameters N_Q0=1.0 L_IN=1e-09 C_IN_SH=1e-12 C_IN_BLK=1e-12 L_BCHOKE=1e-09 R_BBIAS=10000.0 C_BDEC1=1e-12 C_BDEC2=1e-12 R_EMIT=10000.0 C_EBYP=1e-12 R_CFEED=10000.0 C_CDEC=1e-12 L_CCHOKE=1e-09 C_SDEC=1e-12 C_OUT_BLK=1e-12 C_OUT_SH=1e-12 L_OUT=1e-09
Q0 (COLLECTOR BASE EMITTER) gpdk090_npn area=0.5 m=N_Q0
L17 (OUT_MATCH RF_OUT) inductor l=L_OUT
L0 (COL_BIAS COLLECTOR) inductor l=L_CCHOKE
L1 (BASE_BIAS BASE) inductor l=L_BCHOKE
L16 (RF_IN IN_MATCH) inductor l=L_IN
C27 (EMITTER VSS) capacitor c=C_EBYP
C25 (OUT_MATCH VSS) capacitor c=C_OUT_SH
C2 (COLLECTOR OUT_MATCH) capacitor c=C_OUT_BLK
C3 (COL_BIAS VSS) capacitor c=C_CDEC
C4 (VCC VSS) capacitor c=C_SDEC
C6 (BASE_BIAS VSS) capacitor c=C_BDEC1
C5 (BASE_BIAS VSS) capacitor c=C_BDEC2
C1 (IN_MATCH BASE) capacitor c=C_IN_BLK
C24 (IN_MATCH VSS) capacitor c=C_IN_SH
R14 (EMITTER VSS) resistor r=R_EMIT
R5 (VCC COL_BIAS) resistor r=R_CFEED
R3 (BASE_BIAS VCC) resistor r=R_BBIAS
ends pa1088_fig3_dac
