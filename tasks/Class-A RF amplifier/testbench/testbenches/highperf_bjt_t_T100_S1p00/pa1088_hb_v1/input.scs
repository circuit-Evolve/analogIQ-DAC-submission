// analogiq 0.1.0 testbench - generated, do not edit
// task pa1088_dac_task_001  topology pa1088_dac_bench
// recipe pa1088_hb_v1 v1  condition highperf_bjt_t_T100_S1p00 (models highperf_bjt_t, 100 C, supply 12 V)
// request pa1088_dac_task_001__plan  candidate 9b40dcde6eb70295
// execution profile search_full
simulator lang=spectre
global 0
include "<PDK_ROOT>/gpdk090_v4.6/models/spectre/gpdk090_bipolar.scs" section=highperf_bjt_t
include "dut.scs"

parameters pin=-40.0 f0=433000000.0 vsup=12.0
// Supplies (charged to the DUT power metrics).
VSUP (vdd 0) vsource dc=vsup
// External bias (topology external_bias; reported separately as bias power).
VB_VSS (b_VSS 0) vsource dc=0.0

// Measurement instrumentation (replay fixture): 50-ohm ports directly on the RF input and output.
P1 (rfin 0) port r=50.0 num=1 type=sine freq=f0 dbm=pin
P2 (rfout 0) port r=50.0 num=2

XDUT (rfin rfout vdd b_VSS) pa1088_fig3_dac C_BDEC1=1e-12 C_BDEC2=1e-12 C_CDEC=1e-12 C_EBYP=1e-12 C_IN_BLK=1e-12 C_IN_SH=1e-12 C_OUT_BLK=1e-12 C_OUT_SH=1e-12 C_SDEC=1e-12 L_BCHOKE=1e-09 L_CCHOKE=1e-09 L_IN=1e-09 L_OUT=1e-09 N_Q0=1.0 R_BBIAS=10000.0 R_CFEED=10000.0 R_EMIT=10000.0

opts options temp=100.0 tnom=27 reltol=0.0001 save=selected
save P2:p VB_VSS:p VSUP:p rfin rfout vdd

replayopts options reltol=1e-05 vabstol=1e-6 iabstol=1e-12 gmin=1e-12 pivrel=1e-3
swp sweep param=pin start=-40.0 stop=20.0 lin=600 {
hb1 hb fundfreqs=[f0] maxharms=[25] freqdivide=1 errpreset=conservative
}
