simulator lang=spice
.include "models.lib"
simulator lang=spectre
