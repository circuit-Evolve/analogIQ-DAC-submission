// Design: test/poweramp_tb_dac
simulator lang=spectre
global 0
parameters DPAR_4=42 DPAR_3=42 DPAR_2=42 DPAR_1=42 vin_pk=0.174216 pa_L1=10e-6 pa_R24=2200 pa_R19=470 pa_C5=1e-9 pa_C18=10e-9 pa_R22=2200 pa_R21=150 pa_R25=47 pa_C16=100e-9 pa_R17=470 pa_R12=47000 pa_R32=1 pa_C9=1e-9 pa_R15=68000 pa_R14=150 pa_R35=8 sr_edge=1n pa_R2=1000 pa_R9=4700 pa_C12=330e-12 pa_R11=0.33 pa_R34=22 pa_R29=2200 sr_enable=1 pa_R7=10 pa_C19=1e-9 pa_C13=100e-9 pa_R5=1000 pa_R28=2200 pa_R30=2200 pa_C11=100e-9 pa_C7=470e-12 sr_amp=0.87 pa_C8=470e-12 pa_R18=330 pa_R20=47000 pa_C6=100e-12 pa_C3=1e-9 pa_R27=105 pa_R3=3300 pa_R13=220 pa_C2=22e-9 pa_C14=1e-9 pa_R23=2200 pa_R8=4700 pa_R10=10 pa_C15=10e-12 pa_C17=1e-6 pa_R16=330 pa_R4=1000 sr_delay=500u sr_width=100u pa_R1=1000 pa_C10=1e-9 sr_period=2 pa_R26=202.5 pa_R6=15000 pa_C4=100e-12 pa_R31=47 pa_R33=1 pa_C1=10e-9
include "models.scs"

// test/poweramp/schematic_golden
simulator lang=spectre
subckt poweramp ERROR GND IN LOAD OUT REF6 V15 VN VN7 VP inh_bulk_n
parameters input_filter_scale=1
    L1 (OUT LOAD) inductor l=2e-6
    D2 (drive_negative driver_n_base) nscw100
    D1 (driver_p_base drive_positive) nscw100
    D4 (stage1 REF6) dan202um
    D3 (REF6 stage1) dan202um
    Q18 (VP output_p_base output_p_e inh_bulk_n) njw0281g
    Q20 (output_p_base output_bias output_n_base inh_bulk_n) bd139
    Q22 (output_n_base driver_n_base driver_n_e inh_bulk_n) ksc2690a_gp_approx
    Q21 (drive_negative driver_n_base driver_n_buffer_e inh_bulk_n) mmbt6429_kn_approx
    Q15 (bias2n tail2n_e VN7 inh_bulk_n) mmbt6429_kn_approx
    Q14 (tail2n bias2n tail2n_e inh_bulk_n) mmbt6429_kn_approx
    Q13 (drive_positive REF6 diff2n_right inh_bulk_n) mmbt6429_kn_approx
    Q12 (V15 stage1 diff2n_left inh_bulk_n) mmbt6429_kn_approx
    Q7 (bias1 tail1_e VN7 inh_bulk_n) mmbt6429_kn_approx
    Q6 (tail1 bias1 tail1_e inh_bulk_n) mmbt6429_kn_approx
    Q5 (stage1 reference_base tail1 inh_bulk_n) mmbt6429_kn_approx
    Q4 (first_left input_base tail1 inh_bulk_n) mmbt6429_kn_approx
    Q19 (VN output_n_base output_n_e inh_bulk_n) njw0302g
    Q17 (output_p_base driver_p_base driver_p_e inh_bulk_n) ksa1220a_gp_approx
    Q16 (drive_positive driver_p_base driver_p_buffer_e inh_bulk_n) bc857c
    Q11 (drive_negative REF6 diff2p_right inh_bulk_n) bc857c
    Q10 (GND stage1 diff2p_left inh_bulk_n) bc857c
    Q9 (tail2p bias2p tail2p_e inh_bulk_n) bc857c
    Q8 (bias2p tail2p_e V15 inh_bulk_n) bc857c
    Q3 (GND first_left mirror_base inh_bulk_n) bc857c
    Q2 (stage1 mirror_base mirror_e2 inh_bulk_n) bc857c
    Q1 (first_left mirror_base mirror_e1 inh_bulk_n) bc857c
    R35 (LOAD GND) resistor r=8
    R34 (OUT zobel) resistor r=10
    R33 (OUT output_n_e) resistor r=0.1
    R32 (output_p_e OUT) resistor r=0.1
    R27 (output_bias output_n_base) resistor r=70
    R26 (output_p_base output_bias) resistor r=50
    R31 (driver_n_e VN) resistor r=6
    R30 (driver_n_base VN) resistor r=1330
    R29 (driver_n_buffer_e VN) resistor r=1000
    R28 (drive_negative VN) resistor r=1330
    R25 (VP driver_p_e) resistor r=6
    R24 (VP driver_p_base) resistor r=1330
    R23 (VP driver_p_buffer_e) resistor r=1000
    R22 (VP drive_positive) resistor r=1330
    R21 (tail2n_e VN7) resistor r=36
    R20 (GND bias2n) resistor r=10000
    R19 (diff2n_right tail2n) resistor r=100
    R18 (diff2n_left tail2n) resistor r=56
    R17 (tail2p diff2p_right) resistor r=100
    R16 (tail2p diff2p_left) resistor r=56
    R15 (GND bias2p) resistor r=22000
    R14 (V15 tail2p_e) resistor r=38
    R13 (tail1_e VN7) resistor r=35
    R12 (GND bias1) resistor r=12000
    R3 (V15 mirror_base) resistor r=2000
    R2 (V15 mirror_e2) resistor r=411
    R1 (V15 mirror_e1) resistor r=411
    R11 (reference_div ERROR) resistor r=0.18
    R10 (reference_div GND) resistor r=6.65
    R9 (reference_base reference_div) resistor r=2700
    R8 (input_base ERROR) resistor r=3160
    R7 (ERROR GND) resistor r=6.65
    R6 (OUT input_base) resistor r=27000
    R5 (input_filter input_base) resistor r=470
    R4 (input_cap input_filter) resistor r=470
    C19 (LOAD GND) capacitor c=1e-9
    C18 (zobel GND) capacitor c=5e-9
    C11 (output_p_base output_n_base) capacitor c=1e-6
    C8 (driver_n_e VN) capacitor c=1.8e-9
    C10 (drive_negative driver_n_base) capacitor c=10e-9
    C7 (VP driver_p_e) capacitor c=1.8e-9
    C9 (driver_p_base drive_positive) capacitor c=10e-9
    C6 (diff2n_right tail2n) capacitor c=270e-12
    C5 (diff2n_left tail2n) capacitor c=10e-9
    C4 (tail2p diff2p_right) capacitor c=270e-12
    C3 (tail2p diff2p_left) capacitor c=10e-9
    C12 (stage1 OUT) capacitor c=4.7e-11
    C2 (V15 mirror_e2) capacitor c=0.0001
    C1 (V15 mirror_e1) capacitor c=68e-9
    C14 (reference_div GND) capacitor c=10e-9
    C13 (reference_base reference_div) capacitor c=1e-05
    C15 (OUT input_base) capacitor c=1.2e-12
    C16 (input_filter ERROR) capacitor c=15e-9*input_filter_scale
    C17 (IN input_cap) capacitor c=33e-6
ends poweramp

// test/poweramp_tb_dac/schematic
SR_V6 (sr_in sr_error) vsource dc=0 type=pulse delay=sr_delay val0=0 val1=sr_enable*sr_amp period=sr_period rise=sr_edge fall=sr_edge width=sr_width mag=0
SR_V5 (sr_ref6 0) vsource dc=6 type=dc
SR_V7 (sr_error 0) vsource dc=0 type=dc freq=100 ampl=0 sinedc=0 mag=0
SR_V1 (sr_vp 0) vsource dc=DPAR_1 type=dc
SR_V2 (0 sr_vn) vsource dc=DPAR_2 type=dc
SR_V3 (sr_v15 0) vsource dc=15 type=dc
SR_V4 (0 sr_vn7) vsource dc=7 type=dc
V5 (ref6 0) vsource dc=6 type=dc
V4 (0 vn7) vsource dc=7 type=dc
V3 (v15 0) vsource dc=15 type=dc
V2 (0 vn) vsource dc=DPAR_4 type=dc
V1 (vp 0) vsource dc=DPAR_3 type=dc
V7 (error 0) vsource dc=0 type=dc freq=100 ampl=0 sinedc=0 mag=0
V6 (in error) vsource dc=0 type=sine freq=50 ampl=vin_pk sinedc=0 mag=1
XSR (sr_error 0 sr_in sr_load sr_out sr_ref6 sr_v15 sr_vn sr_vn7 sr_vp 0) poweramp input_filter_scale=0
XAMP (error 0 in load out ref6 v15 vn vn7 vp 0) poweramp input_filter_scale=1
simulatorOptions options reltol=1e-6 vabstol=1e-9 temp=27 minr=1u pivotdc=yes dc_pivot_check=yes pivrel=0.1
tran tran stop=650u errpreset=conservative maxstep=2n relref=sigglobal maxiters=50
dcOp dc
extremeinfo info what=all where=logfile extremes=yes
saveOptions options save=selected currents=selected
save out sr_out XAMP.stage1 XAMP.input_base XAMP.Q11:c XAMP.Q13:c XAMP.Q17:c XAMP.Q22:c XAMP.Q18:c XAMP.Q19:c XAMP.Q18:b XAMP.Q19:b
