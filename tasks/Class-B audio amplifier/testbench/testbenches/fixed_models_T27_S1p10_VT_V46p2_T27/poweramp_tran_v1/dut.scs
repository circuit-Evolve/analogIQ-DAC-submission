// Generated by analogiq from dut_benchmark.scs (sha256 777195dceaaf7930).
// Connectivity and device models are unchanged except for the listed transformations:
//   - netlist parameters bound to sizing variables: filter_capacitance_F <- C16
subckt poweramp (ERROR GND IN LOAD OUT REF6 V15 VN VN7 VP inh_bulk_n)
parameters N_Q1_Q2=1.0 N_Q4_Q5=1.0 N_Q10_Q11=1.0 N_Q12_Q13=1.0 N_Q18=1.0 N_Q20=1.0 N_Q22=1.0 N_Q21=1.0 N_Q15=1.0 N_Q14=1.0 N_Q7=1.0 N_Q6=1.0 N_Q19=1.0 N_Q17=1.0 N_Q16=1.0 N_Q9=1.0 N_Q8=1.0 N_Q3=1.0 L1=1e-09 R34=10000.0 R33=10000.0 R32=10000.0 R27=10000.0 R26=10000.0 R31=10000.0 R30=10000.0 R29=10000.0 R28=10000.0 R25=10000.0 R24=10000.0 R23=10000.0 R22=10000.0 R21=10000.0 R20=10000.0 R19=10000.0 R18=10000.0 R17=10000.0 R16=10000.0 R15=10000.0 R14=10000.0 R13=10000.0 R12=10000.0 R3=10000.0 R1=10000.0 R11=10000.0 R10=10000.0 R9=10000.0 R8=10000.0 R7=10000.0 R6=10000.0 R5=10000.0 R4=10000.0 C18=1e-12 C11=1e-12 C8=1e-12 C10=1e-12 C7=1e-12 C9=1e-12 C6=1e-12 C5=1e-12 C4=1e-12 C3=1e-12 C12=1e-12 C2=1e-12 C1=1e-12 C14=1e-12 C13=1e-12 C15=1e-12 C17=1e-12 C16=1e-12 input_filter_scale=1 filter_capacitance_F=C16
L1 (OUT LOAD) inductor l=L1
D2 (drive_negative driver_n_base) nscw100
D1 (driver_p_base drive_positive) nscw100
D4 (stage1 REF6) dan202um
D3 (REF6 stage1) dan202um
Q18 (VP output_p_base output_p_e inh_bulk_n) njw0281g m=N_Q18
Q20 (output_p_base output_bias output_n_base inh_bulk_n) bd139 m=N_Q20
Q22 (output_n_base driver_n_base driver_n_e inh_bulk_n) ksc2690a_gp_approx m=N_Q22
Q21 (drive_negative driver_n_base driver_n_buffer_e inh_bulk_n) mmbt6429_kn_approx m=N_Q21
Q15 (bias2n tail2n_e VN7 inh_bulk_n) mmbt6429_kn_approx m=N_Q15
Q14 (tail2n bias2n tail2n_e inh_bulk_n) mmbt6429_kn_approx m=N_Q14
Q13 (drive_positive REF6 diff2n_right inh_bulk_n) mmbt6429_kn_approx m=N_Q12_Q13
Q12 (V15 stage1 diff2n_left inh_bulk_n) mmbt6429_kn_approx m=N_Q12_Q13
Q7 (bias1 tail1_e VN7 inh_bulk_n) mmbt6429_kn_approx m=N_Q7
Q6 (tail1 bias1 tail1_e inh_bulk_n) mmbt6429_kn_approx m=N_Q6
Q5 (stage1 reference_base tail1 inh_bulk_n) mmbt6429_kn_approx m=N_Q4_Q5
Q4 (first_left input_base tail1 inh_bulk_n) mmbt6429_kn_approx m=N_Q4_Q5
Q19 (VN output_n_base output_n_e inh_bulk_n) njw0302g m=N_Q19
Q17 (output_p_base driver_p_base driver_p_e inh_bulk_n) ksa1220a_gp_approx m=N_Q17
Q16 (drive_positive driver_p_base driver_p_buffer_e inh_bulk_n) bc857c m=N_Q16
Q11 (drive_negative REF6 diff2p_right inh_bulk_n) bc857c m=N_Q10_Q11
Q10 (GND stage1 diff2p_left inh_bulk_n) bc857c m=N_Q10_Q11
Q9 (tail2p bias2p tail2p_e inh_bulk_n) bc857c m=N_Q9
Q8 (bias2p tail2p_e V15 inh_bulk_n) bc857c m=N_Q8
Q3 (GND first_left mirror_base inh_bulk_n) bc857c m=N_Q3
Q2 (stage1 mirror_base mirror_e2 inh_bulk_n) bc857c m=N_Q1_Q2
Q1 (first_left mirror_base mirror_e1 inh_bulk_n) bc857c m=N_Q1_Q2
R35 (LOAD GND) resistor r=8
R34 (OUT zobel) resistor r=R34
R33 (OUT output_n_e) resistor r=R33
R32 (output_p_e OUT) resistor r=R32
R27 (output_bias output_n_base) resistor r=R27
R26 (output_p_base output_bias) resistor r=R26
R31 (driver_n_e VN) resistor r=R31
R30 (driver_n_base VN) resistor r=R30
R29 (driver_n_buffer_e VN) resistor r=R29
R28 (drive_negative VN) resistor r=R28
R25 (VP driver_p_e) resistor r=R25
R24 (VP driver_p_base) resistor r=R24
R23 (VP driver_p_buffer_e) resistor r=R23
R22 (VP drive_positive) resistor r=R22
R21 (tail2n_e VN7) resistor r=R21
R20 (GND bias2n) resistor r=R20
R19 (diff2n_right tail2n) resistor r=R19
R18 (diff2n_left tail2n) resistor r=R18
R17 (tail2p diff2p_right) resistor r=R17
R16 (tail2p diff2p_left) resistor r=R16
R15 (GND bias2p) resistor r=R15
R14 (V15 tail2p_e) resistor r=R14
R13 (tail1_e VN7) resistor r=R13
R12 (GND bias1) resistor r=R12
R3 (V15 mirror_base) resistor r=R3
R2 (V15 mirror_e2) resistor r=R1
R1 (V15 mirror_e1) resistor r=R1
R11 (reference_div ERROR) resistor r=R11
R10 (reference_div GND) resistor r=R10
R9 (reference_base reference_div) resistor r=R9
R8 (input_base ERROR) resistor r=R8
R7 (ERROR GND) resistor r=R7
R6 (OUT input_base) resistor r=R6
R5 (input_filter input_base) resistor r=R5
R4 (input_cap input_filter) resistor r=R4
C19 (LOAD GND) capacitor c=1e-9
C18 (zobel GND) capacitor c=C18
C11 (output_p_base output_n_base) capacitor c=C11
C8 (driver_n_e VN) capacitor c=C8
C10 (drive_negative driver_n_base) capacitor c=C10
C7 (VP driver_p_e) capacitor c=C7
C9 (driver_p_base drive_positive) capacitor c=C9
C6 (diff2n_right tail2n) capacitor c=C6
C5 (diff2n_left tail2n) capacitor c=C5
C4 (tail2p diff2p_right) capacitor c=C4
C3 (tail2p diff2p_left) capacitor c=C3
C12 (stage1 OUT) capacitor c=C12
C2 (V15 mirror_e2) capacitor c=C2
C1 (V15 mirror_e1) capacitor c=C1
C14 (reference_div GND) capacitor c=C14
C13 (reference_base reference_div) capacitor c=C13
C15 (OUT input_base) capacitor c=C15
C16 (input_filter ERROR) capacitor c=filter_capacitance_F*input_filter_scale
C17 (IN input_cap) capacitor c=C17
ends poweramp
