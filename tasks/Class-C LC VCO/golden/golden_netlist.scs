// Golden sizing netlist (curator 2026-10-28): the benchmark DUT subckt with its parameter defaults set to
// the golden design (golden_design.json), taken from the verified run's job tt_T25_S0p83/osc_pnoise_v1.
// The DUT subckt and its parameter values are the same in every job of that run (only the testbench changes).
// Instance line of that run: XDUT (vdd b_VSS b_VBIAS b_VTAIL b_VCOM open_CMP_SENSE outp outn open_AUXP open_AUXN) repaired_core C_BIAS=2.0841217202451464e-11 C_COUP=1.083198159253043e-14 C_FILT=6.099729891242877e-13 C_PAR=1.74109...
// Testbench-level variables (bias sources, operating levels) are in golden_design.json and testbench decks.
// Generated by analogiq from dut_benchmark.scs (sha256 23c8236977d815cf).
// Connectivity and device models are unchanged except for the listed transformations:
//   - M1: mult bound to N_CORE; Spectre multiplicity m follows it
//   - M1: junction geometry ad/as/pd/ps rewritten in terms of the bound width (area = Lj*W, perimeter = 2*W + c; Lj and c from the netlist)
//   - M2: mult bound to N_CORE; Spectre multiplicity m follows it
//   - M2: junction geometry ad/as/pd/ps rewritten in terms of the bound width (area = Lj*W, perimeter = 2*W + c; Lj and c from the netlist)
//   - M3: mult bound to N_AUX; Spectre multiplicity m follows it
//   - M3: junction geometry ad/as/pd/ps rewritten in terms of the bound width (area = Lj*W, perimeter = 2*W + c; Lj and c from the netlist)
//   - M4: mult bound to N_AUX; Spectre multiplicity m follows it
//   - M4: junction geometry ad/as/pd/ps rewritten in terms of the bound width (area = Lj*W, perimeter = 2*W + c; Lj and c from the netlist)
//   - MT1: mult bound to N_MT1; Spectre multiplicity m follows it
//   - MT1: junction geometry ad/as/pd/ps rewritten in terms of the bound width (area = Lj*W, perimeter = 2*W + c; Lj and c from the netlist)
//   - MT: mult bound to N_MT; Spectre multiplicity m follows it
//   - MT: junction geometry ad/as/pd/ps rewritten in terms of the bound width (area = Lj*W, perimeter = 2*W + c; Lj and c from the netlist)
//   - netlist parameters bound to sizing variables: W_AUX <- W_AUX, W_CORE <- W_CORE, W_MT <- W_MT, W_MT1 <- W_MT1
subckt repaired_core (VDD VSS VBIAS VTAIL VCOM CMP_SENSE OUTP OUTN AUXP AUXN)
parameters W_CORE=1.3060651585834978e-06 L_CORE=1.7624787201398927e-07 NF_CORE=48.0 N_CORE=9.0 W_AUX=2.6642907696164027e-06 L_AUX=1.1176738283983767e-05 NF_AUX=52.0 N_AUX=70.0 W_MT1=1.2799032665068938e-05 L_MT1=1.496673118101575e-06 NF_MT1=72.0 N_MT1=72.0 W_MT=4.372181627219309e-05 L_MT=8.99336148818903e-07 NF_MT=49.0 N_MT=74.0 L_MAIN=1.502773408294349e-09 LI_AUX=2.222560870382872e-10 C_COUP=1.083198159253043e-14 C_PAR=1.7410997366977215e-14 C_BIAS=2.0841217202451464e-11 R_BIAS=137808.05238766776 C_FILT=6.099729891242877e-13 C_TAIL=3.203401066874221e-11
M1 (OUTP G1 CMP_SENSE VSS) sky130_fd_pr__nfet_01v8 w=((W_CORE*NF_CORE)/1e-06) l=(L_CORE/1e-06) nf=NF_CORE mult=N_CORE ad=(0.14500000000000002*(((W_CORE*NF_CORE)/1e-06))) as=(0.1611111111111111*(((W_CORE*NF_CORE)/1e-06))) pd=max(2*(((W_CORE*NF_CORE)/1e-06))+(-89.28),0) ps=max(2*(((W_CORE*NF_CORE)/1e-06))+(-78.2),0) sa=0 sb=0 sd=0 m=N_CORE
M2 (OUTN G2 CMP_SENSE VSS) sky130_fd_pr__nfet_01v8 w=((W_CORE*NF_CORE)/1e-06) l=(L_CORE/1e-06) nf=NF_CORE mult=N_CORE ad=(0.14500000000000002*(((W_CORE*NF_CORE)/1e-06))) as=(0.1611111111111111*(((W_CORE*NF_CORE)/1e-06))) pd=max(2*(((W_CORE*NF_CORE)/1e-06))+(-89.28),0) ps=max(2*(((W_CORE*NF_CORE)/1e-06))+(-78.2),0) sa=0 sb=0 sd=0 m=N_CORE
M3 (AUXP AUXN AUXTAIL VSS) sky130_fd_pr__nfet_01v8 w=((W_AUX*NF_AUX)/1e-06) l=(L_AUX/1e-06) nf=NF_AUX mult=N_AUX ad=(0.145*(((W_AUX*NF_AUX)/1e-06))) as=(0.29*(((W_AUX*NF_AUX)/1e-06))) pd=max(2*(((W_AUX*NF_AUX)/1e-06))+(-8.42),0) ps=max(2*(((W_AUX*NF_AUX)/1e-06))+(1.1600000000000001),0) sa=0 sb=0 sd=0 m=N_AUX
M4 (AUXN AUXP AUXTAIL VSS) sky130_fd_pr__nfet_01v8 w=((W_AUX*NF_AUX)/1e-06) l=(L_AUX/1e-06) nf=NF_AUX mult=N_AUX ad=(0.145*(((W_AUX*NF_AUX)/1e-06))) as=(0.29*(((W_AUX*NF_AUX)/1e-06))) pd=max(2*(((W_AUX*NF_AUX)/1e-06))+(-8.42),0) ps=max(2*(((W_AUX*NF_AUX)/1e-06))+(1.1600000000000001),0) sa=0 sb=0 sd=0 m=N_AUX
MT1 (AUXTAIL VCOM VSS VSS) sky130_fd_pr__nfet_01v8 w=((W_MT1*NF_MT1)/1e-06) l=(L_MT1/1e-06) nf=NF_MT1 mult=N_MT1 ad=(0.145*(((W_MT1*NF_MT1)/1e-06))) as=(0.16916666666666666*(((W_MT1*NF_MT1)/1e-06))) pd=max(2*(((W_MT1*NF_MT1)/1e-06))+(-44.52),0) ps=max(2*(((W_MT1*NF_MT1)/1e-06))+(-35.94),0) sa=0 sb=0 sd=0 m=N_MT1
MT (CMP_SENSE VTAIL VSS VSS) sky130_fd_pr__nfet_01v8 w=((W_MT*NF_MT)/1e-06) l=(L_MT/1e-06) nf=NF_MT mult=N_MT ad=(0.145*(((W_MT*NF_MT)/1e-06))) as=(0.147265625*(((W_MT*NF_MT)/1e-06))) pd=max(2*(((W_MT*NF_MT)/1e-06))+(-474.88),0) ps=max(2*(((W_MT*NF_MT)/1e-06))+(-466.29999999999995),0) sa=0 sb=0 sd=0 m=N_MT
LP (VDD XLP) inductor l=L_MAIN
RLP (XLP OUTP) resistor r=(2*3.14159265*3.4e9*L_MAIN/10)
LAP (VDD XLAP) inductor l=LI_AUX
RLAP (XLAP AUXP) resistor r=(2*3.14159265*3.4e9*LI_AUX/10)
LAN (VDD XLAN) inductor l=LI_AUX
RLAN (XLAN AUXN) resistor r=(2*3.14159265*3.4e9*LI_AUX/10)
LN (VDD XLN) inductor l=L_MAIN
RLN (XLN OUTN) resistor r=(2*3.14159265*3.4e9*L_MAIN/10)
C2P (VDD OUTP) capacitor c=C_PAR
C2N (VDD OUTN) capacitor c=C_PAR
C1P (OUTP AUXP) capacitor c=C_COUP
C1N (OUTN AUXN) capacitor c=C_COUP
CBP (OUTP G2) capacitor c=C_BIAS
CBN (OUTN G1) capacitor c=C_BIAS
RBP (VBIAS G1) resistor r=R_BIAS
RBN (VBIAS G2) resistor r=R_BIAS
CF (VCOM VSS) capacitor c=C_FILT
CT (CMP_SENSE VSS) capacitor c=C_TAIL
ends repaired_core
