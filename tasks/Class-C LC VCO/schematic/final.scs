simulator lang=spectre
include "<PDK_ROOT>/sky130_cds/spectre/libs.tech/combined/sky130.lib.spice" section=tt
subckt repaired_core VDD VSS VBIAS VTAIL VCOM CMP_SENSE OUTP OUTN AUXP AUXN
M1 (OUTP G1 CMP_SENSE VSS) sky130_fd_pr__nfet_01v8 w=94.5 l=.15 nf=18 mult=1 ad=13.7025 as=15.225 pd=99.72 ps=110.8 sa=0 sb=0 sd=0 m=1
M2 (OUTN G2 CMP_SENSE VSS) sky130_fd_pr__nfet_01v8 w=94.5 l=.15 nf=18 mult=1 ad=13.7025 as=15.225 pd=99.72 ps=110.8 sa=0 sb=0 sd=0 m=1
M3 (AUXP AUXN AUXTAIL VSS) sky130_fd_pr__nfet_01v8 w=9 l=.15 nf=2 mult=1 ad=1.305 as=2.61 pd=9.58 ps=19.16 sa=0 sb=0 sd=0 m=1
M4 (AUXN AUXP AUXTAIL VSS) sky130_fd_pr__nfet_01v8 w=9 l=.15 nf=2 mult=1 ad=1.305 as=2.61 pd=9.58 ps=19.16 sa=0 sb=0 sd=0 m=1
MT1 (AUXTAIL VCOM VSS VSS) sky130_fd_pr__nfet_01v8 w=48 l=.35 nf=12 mult=1 ad=6.96 as=8.12 pd=51.48 ps=60.06 sa=0 sb=0 sd=0 m=1
MT (CMP_SENSE VTAIL VSS VSS) sky130_fd_pr__nfet_01v8 w=512 l=.35 nf=128 mult=1 ad=74.24 as=75.4 pd=549.12 ps=557.7 sa=0 sb=0 sd=0 m=1
LP (VDD OUTP) inductor l=1.6n
LAP (VDD AUXP) inductor l=1.6n
LAN (VDD AUXN) inductor l=1.6n
LN (VDD OUTN) inductor l=1.6n
C2P (VDD OUTP) capacitor c=2.5p
C2N (VDD OUTN) capacitor c=2.5p
C1P (OUTP AUXP) capacitor c=3p
C1N (OUTN AUXN) capacitor c=3p
CBP (OUTP G2) capacitor c=420f
CBN (OUTN G1) capacitor c=420f
RBP (VBIAS G1) resistor r=2.5K
RBN (VBIAS G2) resistor r=2.5K
CF (VCOM VSS) capacitor c=645f
CT (CMP_SENSE VSS) capacitor c=23.3p
ends repaired_core
