// analogiq 0.1.0 testbench - generated, do not edit
// task lcvco24_sheikhahmadi_task_001  topology lcvco24_sheikhahmadi
// recipe osc_pnoise_v1 v3  condition ff_Tm20_S1p17 (models ff, -20 C, supply 1.4 V)
// request lcvco24_sheikhahmadi_task_001__plan  candidate 28d54c6829c7e5cb
// execution profile search_full
simulator lang=spectre
global 0
include "<PDK_ROOT>/sky130_cds/spectre/libs.tech/combined/sky130.lib.spice" section=ff
include "dut.scs"

parameters cl=1e-14 vsup=1.40000004
// Sizing variables set in the testbench (external-bias values).
parameters V_BIAS={{V_BIAS}} V_TAIL={{V_TAIL}}
// Supplies (charged to the DUT power metrics).
VSUP (vdd 0) vsource dc=vsup
// External bias (topology external_bias; reported separately as bias power).
VB_VSS (b_VSS 0) vsource dc=0.0
VB_VBIAS (b_VBIAS 0) vsource dc=V_BIAS
VB_VTAIL (b_VTAIL 0) vsource dc=V_TAIL
VB_VCOM (b_VCOM 0) vsource dc=0.0

CL1 (outp 0) capacitor c=cl
CL2 (outn 0) capacitor c=cl
// Start-up kick: current pulse into outp (start-up assistance, see recipe doc).
IKICK (0 outp) isource type=pulse val0=0 val1=0.001 delay=0 rise=5.0000000000000005e-12 fall=5.0000000000000005e-12 width=5e-11

XDUT (vdd b_VSS b_VBIAS b_VTAIL b_VCOM open_CMP_SENSE outp outn open_AUXP open_AUXN) repaired_core C_BIAS={{C_BIAS}} C_COUP={{C_COUP}} C_FILT={{C_FILT}} C_PAR={{C_PAR}} C_TAIL={{C_TAIL}} LI_AUX={{LI_AUX}} L_AUX={{L_AUX}} L_CORE={{L_CORE}} L_MAIN={{L_MAIN}} L_MT={{L_MT}} L_MT1={{L_MT1}} NF_AUX={{NF_AUX}} NF_CORE={{NF_CORE}} NF_MT={{NF_MT}} NF_MT1={{NF_MT1}} N_AUX={{N_AUX}} N_CORE={{N_CORE}} N_MT={{N_MT}} N_MT1={{N_MT1}} R_BIAS={{R_BIAS}} W_AUX={{W_AUX}} W_CORE={{W_CORE}} W_MT={{W_MT}} W_MT1={{W_MT1}}

opts options temp=-20.0 tnom=27 reltol=0.0001 save=selected
save VB_VBIAS:p VB_VCOM:p VB_VSS:p VB_VTAIL:p VSUP:p outn outp vdd

pss1 (outp outn) pss fund=3800000000.0 harms=10 tstab=6e-08 errpreset=conservative
pn1 (outp outn) pnoise start=500000.0 stop=20000000.0 dec=10 maxsideband=10 sweeptype=relative relharmnum=1 noisetype=timeaverage
