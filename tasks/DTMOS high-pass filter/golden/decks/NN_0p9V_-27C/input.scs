// Design: DAC_DTMOS_HPF_REPAIR_20261109/DTMOS_CANDIDATE_STB_tb
simulator lang=spectre
global 0
include "<PDK_ROOT>/gpdk180/models/spectre/gpdk.scs" section=NN

// DAC_DTMOS_HPF_REPAIR_20261109/dtmos_candidate_stb/schematic
subckt dtmos_candidate_stb GND IN OUT VDD VSS
    M3 (NB3 IN N1 VDD) pmos1 w=9.56513378824e-06 l=2.63452442545e-06 m=2
    Mpb8 (OUT PHP VDD VDD) pmos1 w=7.50085947324e-05 l=6.80757910978e-06 m=1
    Mpb7 (PHP PHP VDD VDD) pmos1 w=1.56075006816e-05 l=6.80757910978e-06 m=1
    Mpb6 (OUT PLP VDD VDD) pmos1 w=4.28178801053e-05 l=4.71256651269e-07 m=1
    Mpb5 (PLP PLP VDD VDD) pmos1 w=4.28178801053e-05 l=4.71256651269e-07 m=1
    Mpb4 (PB1 PB1 VDD PB1) pmos1 w=0.0001 l=1.8e-07 m=1
    Mpb3 (N2 PB1 VDD PB1) pmos1 w=7.5e-05 l=1.8e-07 m=1
    Mpb2 (PB2 PB2 VDD PB2) pmos1 w=0.0001 l=1.8e-07 m=242
    Mpb1 (N1 PB2 VDD PB2) pmos1 w=0.0001 l=1.8e-07 m=242
    Mnb5 (OUT N1 VSS VSS) nmos1 w=6.22154590196e-07 l=7.72725716763e-06 m=1
    Mnb4 (PHP NB3 VSS VSS) nmos1 w=2.06581058078e-05 l=6.38343835136e-07 m=1
    Mnb3 (NB3 NB3 VSS VSS) nmos1 w=8.87452720866e-06 l=3.13363128146e-07 m=1
    Mnb2 (IN NB0 VSS VSS) nmos1 w=2.24870520279e-05 l=4.50312118489e-07 m=1
    Mnb1 (NB0 NB0 VSS VSS) nmos1 w=2.24870520279e-05 l=4.50312118489e-07 m=1
    M4 (VDD N2_M4 IN VSS) nmos1 w=2.25899682093e-05 l=1.81490778558e-06 m=1
    M2 (PLP N2 GND VSS) nmos1 w=4.51799364185e-06 l=1.81490778558e-06 m=1
    M1 (N2 N1 VSS VSS) nmos1 w=7.5e-07 l=8e-06 m=1
    I0 (GND NB0) isource dc=4.5e-05 type=dc
    IB2 (PB2 GND) isource dc=6e-06 type=dc
    IB1 (PB1 GND) isource dc=3e-05 type=dc
    C2 (N2 GND) capacitor c=9.08083910592e-07
    C1 (N1 GND) capacitor c=7.06731530513e-08
    IP_STB (N2 N2_M4) iprobe
ends dtmos_candidate_stb

// DAC_DTMOS_HPF_REPAIR_20261109/DTMOS_CANDIDATE_STB_tb/schematic
DUT (0 IN OUT VDD VSS) dtmos_candidate_stb
VOUT_SENSE (OUT 0) vsource dc=0 type=dc
VSS_SRC (VSS 0) vsource dc=-0.9 type=dc
VDD_SRC (VDD 0) vsource dc=0.9 type=dc
IIN_SRC (0 IN) isource mag=1 type=sine sinedc=0 ampl=5u freq=500
simulatorOptions options reltol=1e-07 vabstol=1e-09 iabstol=1e-14 temp=-27
stb stb start=1m stop=10G dec=100 probe=DUT.IP_STB
ac ac start=1 stop=10M dec=100
dcOp dc
saveOptions options currents=all subcktprobelvl=5

tran tran stop=60m errpreset=conservative maxstep=1u strobeperiod=1u method=gear2only
