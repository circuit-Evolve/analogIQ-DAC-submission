// analogiq 0.1.0 testbench - generated, do not edit
// task dtmos_hpf_101126_task_001  topology dtmos_hpf_101126
// recipe hpf1111_ithd_v1 v1  condition NN_T100_S1p00 (models NN, 100 C, supply 0.9 V)
// request dtmos_hpf_101126_task_001__plan  candidate eac6ca687d6d919d
// execution profile search_full
simulator lang=spectre
global 0
include "<CADENCE_SHARED>/FOUNDRY/analog/180nm/models/spectre/gpdk.scs" section=NN
include "dut.scs"

parameters vsup=0.9 vneg=-0.9
// Supplies (charged to the DUT power metrics).
VSUP (vdd 0) vsource dc=vsup
VNEG (vss 0) vsource dc=vneg
// External bias (topology external_bias; reported separately as bias power).
VB_GND (b_GND 0) vsource dc=0.0

// Current-mode drive: sine input current into the input pin; output held by VOUT (current sense).
IIN (0 iin) isource type=sine sinedc=0.0 ampl=5e-06 freq=500.0
VOUT (out 0) vsource dc=0.0

XDUT (b_GND iin out vdd vss) dtmos_candidate_stb C1={{C1}} C2={{C2}} I0={{I0}} IB1={{IB1}} IB2={{IB2}} L_M1={{L_M1}} L_M24={{L_M24}} L_M3={{L_M3}} L_MNB12={{L_MNB12}} L_MNB3={{L_MNB3}} L_MNB4={{L_MNB4}} L_MNB5={{L_MNB5}} L_MPB12={{L_MPB12}} L_MPB34={{L_MPB34}} L_MPB56={{L_MPB56}} L_MPB78={{L_MPB78}} M_M1={{M_M1}} M_M2={{M_M2}} M_M3={{M_M3}} M_M4={{M_M4}} M_MNB12={{M_MNB12}} M_MNB3={{M_MNB3}} M_MNB4={{M_MNB4}} M_MNB5={{M_MNB5}} M_MPB12={{M_MPB12}} M_MPB3={{M_MPB3}} M_MPB4={{M_MPB4}} M_MPB56={{M_MPB56}} M_MPB7={{M_MPB7}} M_MPB8={{M_MPB8}} W_M1={{W_M1}} W_M2={{W_M2}} W_M3={{W_M3}} W_M4={{W_M4}} W_MNB12={{W_MNB12}} W_MNB3={{W_MNB3}} W_MNB4={{W_MNB4}} W_MNB5={{W_MNB5}} W_MPB12={{W_MPB12}} W_MPB3={{W_MPB3}} W_MPB4={{W_MPB4}} W_MPB56={{W_MPB56}} W_MPB7={{W_MPB7}} W_MPB8={{W_MPB8}}

opts options temp=100.0 tnom=27 reltol=0.0001 save=selected
save VB_GND:p VNEG:p VOUT:p VSUP:p iin out vdd vss

hpfopts options iabstol=1e-14
tr1 tran stop=0.06 maxstep=1e-06 errpreset=conservative method=gear2only
