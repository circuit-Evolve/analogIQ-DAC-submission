// Generated by analogiq from dut_benchmark.scs (sha256 ab39d29eead65829).
// Connectivity and device models are unchanged except for the listed transformations:
//   - ideal elements kept inside the DUT: I0, IB2, IB1
//   - M3: junction geometry as/ad/ps/pd rewritten in terms of the bound width (area = Lj*W, perimeter = 2*W + c; Lj and c from the netlist)
//   - Mpb8: junction geometry as/ad/ps/pd rewritten in terms of the bound width (area = Lj*W, perimeter = 2*W + c; Lj and c from the netlist)
//   - Mpb7: junction geometry as/ad/ps/pd rewritten in terms of the bound width (area = Lj*W, perimeter = 2*W + c; Lj and c from the netlist)
//   - Mpb6: junction geometry as/ad/ps/pd rewritten in terms of the bound width (area = Lj*W, perimeter = 2*W + c; Lj and c from the netlist)
//   - Mpb5: junction geometry as/ad/ps/pd rewritten in terms of the bound width (area = Lj*W, perimeter = 2*W + c; Lj and c from the netlist)
//   - Mpb4: junction geometry as/ad/ps/pd rewritten in terms of the bound width (area = Lj*W, perimeter = 2*W + c; Lj and c from the netlist)
//   - Mpb3: junction geometry as/ad/ps/pd rewritten in terms of the bound width (area = Lj*W, perimeter = 2*W + c; Lj and c from the netlist)
//   - Mpb2: junction geometry as/ad/ps/pd rewritten in terms of the bound width (area = Lj*W, perimeter = 2*W + c; Lj and c from the netlist)
//   - Mpb1: junction geometry as/ad/ps/pd rewritten in terms of the bound width (area = Lj*W, perimeter = 2*W + c; Lj and c from the netlist)
//   - Mnb5: junction geometry as/ad/ps/pd rewritten in terms of the bound width (area = Lj*W, perimeter = 2*W + c; Lj and c from the netlist)
//   - Mnb4: junction geometry as/ad/ps/pd rewritten in terms of the bound width (area = Lj*W, perimeter = 2*W + c; Lj and c from the netlist)
//   - Mnb3: junction geometry as/ad/ps/pd rewritten in terms of the bound width (area = Lj*W, perimeter = 2*W + c; Lj and c from the netlist)
//   - Mnb2: junction geometry as/ad/ps/pd rewritten in terms of the bound width (area = Lj*W, perimeter = 2*W + c; Lj and c from the netlist)
//   - Mnb1: junction geometry as/ad/ps/pd rewritten in terms of the bound width (area = Lj*W, perimeter = 2*W + c; Lj and c from the netlist)
//   - M4: junction geometry as/ad/ps/pd rewritten in terms of the bound width (area = Lj*W, perimeter = 2*W + c; Lj and c from the netlist)
//   - M2: junction geometry as/ad/ps/pd rewritten in terms of the bound width (area = Lj*W, perimeter = 2*W + c; Lj and c from the netlist)
//   - M1: junction geometry as/ad/ps/pd rewritten in terms of the bound width (area = Lj*W, perimeter = 2*W + c; Lj and c from the netlist)
//   - widths bound to sizing variables on fold-capable devices are folded symbolically into ceil(W/max) fingers of W/ceil(W/max) (per-device max [0.0001] m): M1, M2, M3, M4, Mnb1, Mnb2, Mnb3, Mnb4, Mnb5, Mpb1, Mpb2, Mpb3, Mpb4, Mpb5, Mpb6, Mpb7, Mpb8
subckt dtmos_candidate_stb (GND IN OUT VDD VSS)
parameters W_M1=1e-06 L_M1=1e-06 W_M2=1e-06 W_M4=1e-06 L_M24=1e-06 W_M3=1e-06 M_M3=1.0 L_M3=1e-06 W_MPB12=1e-06 M_MPB12=1.0 L_MPB12=1e-06 W_MPB3=1e-06 W_MPB4=1e-06 L_MPB34=1e-06 W_MPB56=1e-06 L_MPB56=1e-06 W_MPB7=1e-06 W_MPB8=1e-06 L_MPB78=1e-06 W_MNB12=1e-06 L_MNB12=1e-06 W_MNB3=1e-06 L_MNB3=1e-06 W_MNB4=1e-06 L_MNB4=1e-06 W_MNB5=1e-06 L_MNB5=1e-06 C1=1e-12 C2=1e-12 I0=1e-05 IB1=1e-05 IB2=1e-05 M_M1=1.0 M_M2=1.0 M_M4=1.0 M_MPB3=1.0 M_MPB4=1.0 M_MPB56=1.0 M_MPB7=1.0 M_MPB8=1.0 M_MNB12=1.0 M_MNB3=1.0 M_MNB4=1.0 M_MNB5=1.0
M3 (NB3 IN N1 VDD) pmos1 w=(W_M3/ceil(W_M3/0.0001-1e-9)) l=L_M3 as=(4.0000000000041815e-07*((W_M3/ceil(W_M3/0.0001-1e-9)))) ad=(4.0000000000041815e-07*((W_M3/ceil(W_M3/0.0001-1e-9)))) ps=max(2*((W_M3/ceil(W_M3/0.0001-1e-9)))+(8.000000000199993e-07),0) pd=max(2*((W_M3/ceil(W_M3/0.0001-1e-9)))+(8.000000000199993e-07),0) m=M_M3*ceil(W_M3/0.0001-1e-9)
Mpb8 (OUT PHP VDD VDD) pmos1 w=(W_MPB8/ceil(W_MPB8/0.0001-1e-9)) l=L_MPB78 as=(4.0000000000053324e-07*((W_MPB8/ceil(W_MPB8/0.0001-1e-9)))) ad=(4.0000000000053324e-07*((W_MPB8/ceil(W_MPB8/0.0001-1e-9)))) ps=max(2*((W_MPB8/ceil(W_MPB8/0.0001-1e-9)))+(7.999999991999867e-07),0) pd=max(2*((W_MPB8/ceil(W_MPB8/0.0001-1e-9)))+(7.999999991999867e-07),0) m=M_MPB8*ceil(W_MPB8/0.0001-1e-9)
Mpb7 (PHP PHP VDD VDD) pmos1 w=(W_MPB7/ceil(W_MPB7/0.0001-1e-9)) l=L_MPB78 as=(4.0000000000128144e-07*((W_MPB7/ceil(W_MPB7/0.0001-1e-9)))) ad=(4.0000000000128144e-07*((W_MPB7/ceil(W_MPB7/0.0001-1e-9)))) ps=max(2*((W_MPB7/ceil(W_MPB7/0.0001-1e-9)))+(8.000000001000032e-07),0) pd=max(2*((W_MPB7/ceil(W_MPB7/0.0001-1e-9)))+(8.000000001000032e-07),0) m=M_MPB7*ceil(W_MPB7/0.0001-1e-9)
Mpb6 (OUT PLP VDD VDD) pmos1 w=(W_MPB56/ceil(W_MPB56/0.0001-1e-9)) l=L_MPB56 as=(3.9999999999953295e-07*((W_MPB56/ceil(W_MPB56/0.0001-1e-9)))) ad=(3.9999999999953295e-07*((W_MPB56/ceil(W_MPB56/0.0001-1e-9)))) ps=max(2*((W_MPB56/ceil(W_MPB56/0.0001-1e-9)))+(8.000000000999964e-07),0) pd=max(2*((W_MPB56/ceil(W_MPB56/0.0001-1e-9)))+(8.000000000999964e-07),0) m=M_MPB56*ceil(W_MPB56/0.0001-1e-9)
Mpb5 (PLP PLP VDD VDD) pmos1 w=(W_MPB56/ceil(W_MPB56/0.0001-1e-9)) l=L_MPB56 as=(3.9999999999953295e-07*((W_MPB56/ceil(W_MPB56/0.0001-1e-9)))) ad=(3.9999999999953295e-07*((W_MPB56/ceil(W_MPB56/0.0001-1e-9)))) ps=max(2*((W_MPB56/ceil(W_MPB56/0.0001-1e-9)))+(8.000000000999964e-07),0) pd=max(2*((W_MPB56/ceil(W_MPB56/0.0001-1e-9)))+(8.000000000999964e-07),0) m=M_MPB56*ceil(W_MPB56/0.0001-1e-9)
Mpb4 (PB1 PB1 VDD PB1) pmos1 w=(W_MPB4/ceil(W_MPB4/0.0001-1e-9)) l=L_MPB34 as=(4e-07*((W_MPB4/ceil(W_MPB4/0.0001-1e-9)))) ad=(4e-07*((W_MPB4/ceil(W_MPB4/0.0001-1e-9)))) ps=max(2*((W_MPB4/ceil(W_MPB4/0.0001-1e-9)))+(7.999999999999923e-07),0) pd=max(2*((W_MPB4/ceil(W_MPB4/0.0001-1e-9)))+(7.999999999999923e-07),0) m=M_MPB4*ceil(W_MPB4/0.0001-1e-9)
Mpb3 (N2 PB1 VDD PB1) pmos1 w=(W_MPB3/ceil(W_MPB3/0.0001-1e-9)) l=L_MPB34 as=(4.0000000000000003e-07*((W_MPB3/ceil(W_MPB3/0.0001-1e-9)))) ad=(4.0000000000000003e-07*((W_MPB3/ceil(W_MPB3/0.0001-1e-9)))) ps=max(2*((W_MPB3/ceil(W_MPB3/0.0001-1e-9)))+(8.000000000000194e-07),0) pd=max(2*((W_MPB3/ceil(W_MPB3/0.0001-1e-9)))+(8.000000000000194e-07),0) m=M_MPB3*ceil(W_MPB3/0.0001-1e-9)
Mpb2 (PB2 PB2 VDD PB2) pmos1 w=(W_MPB12/ceil(W_MPB12/0.0001-1e-9)) l=L_MPB12 as=(4e-07*((W_MPB12/ceil(W_MPB12/0.0001-1e-9)))) ad=(4e-07*((W_MPB12/ceil(W_MPB12/0.0001-1e-9)))) ps=max(2*((W_MPB12/ceil(W_MPB12/0.0001-1e-9)))+(7.999999999999923e-07),0) pd=max(2*((W_MPB12/ceil(W_MPB12/0.0001-1e-9)))+(7.999999999999923e-07),0) m=M_MPB12*ceil(W_MPB12/0.0001-1e-9)
Mpb1 (N1 PB2 VDD PB2) pmos1 w=(W_MPB12/ceil(W_MPB12/0.0001-1e-9)) l=L_MPB12 as=(4e-07*((W_MPB12/ceil(W_MPB12/0.0001-1e-9)))) ad=(4e-07*((W_MPB12/ceil(W_MPB12/0.0001-1e-9)))) ps=max(2*((W_MPB12/ceil(W_MPB12/0.0001-1e-9)))+(7.999999999999923e-07),0) pd=max(2*((W_MPB12/ceil(W_MPB12/0.0001-1e-9)))+(7.999999999999923e-07),0) m=M_MPB12*ceil(W_MPB12/0.0001-1e-9)
Mnb5 (OUT N1 VSS VSS) nmos1 w=(W_MNB5/ceil(W_MNB5/0.0001-1e-9)) l=L_MNB5 as=(3.999999999993571e-07*((W_MNB5/ceil(W_MNB5/0.0001-1e-9)))) ad=(3.999999999993571e-07*((W_MNB5/ceil(W_MNB5/0.0001-1e-9)))) ps=max(2*((W_MNB5/ceil(W_MNB5/0.0001-1e-9)))+(7.999999999980001e-07),0) pd=max(2*((W_MNB5/ceil(W_MNB5/0.0001-1e-9)))+(7.999999999980001e-07),0) m=M_MNB5*ceil(W_MNB5/0.0001-1e-9)
Mnb4 (PHP NB3 VSS VSS) nmos1 w=(W_MNB4/ceil(W_MNB4/0.0001-1e-9)) l=L_MNB4 as=(3.999999999990318e-07*((W_MNB4/ceil(W_MNB4/0.0001-1e-9)))) ad=(3.999999999990318e-07*((W_MNB4/ceil(W_MNB4/0.0001-1e-9)))) ps=max(2*((W_MNB4/ceil(W_MNB4/0.0001-1e-9)))+(7.999999998000045e-07),0) pd=max(2*((W_MNB4/ceil(W_MNB4/0.0001-1e-9)))+(7.999999998000045e-07),0) m=M_MNB4*ceil(W_MNB4/0.0001-1e-9)
Mnb3 (NB3 NB3 VSS VSS) nmos1 w=(W_MNB3/ceil(W_MNB3/0.0001-1e-9)) l=L_MNB3 as=(3.9999999999954925e-07*((W_MNB3/ceil(W_MNB3/0.0001-1e-9)))) ad=(3.9999999999954925e-07*((W_MNB3/ceil(W_MNB3/0.0001-1e-9)))) ps=max(2*((W_MNB3/ceil(W_MNB3/0.0001-1e-9)))+(7.99999999979999e-07),0) pd=max(2*((W_MNB3/ceil(W_MNB3/0.0001-1e-9)))+(7.99999999979999e-07),0) m=M_MNB3*ceil(W_MNB3/0.0001-1e-9)
Mnb2 (IN NB0 VSS VSS) nmos1 w=(W_MNB12/ceil(W_MNB12/0.0001-1e-9)) l=L_MNB12 as=(4.000000000008894e-07*((W_MNB12/ceil(W_MNB12/0.0001-1e-9)))) ad=(4.000000000008894e-07*((W_MNB12/ceil(W_MNB12/0.0001-1e-9)))) ps=max(2*((W_MNB12/ceil(W_MNB12/0.0001-1e-9)))+(8.000000000999964e-07),0) pd=max(2*((W_MNB12/ceil(W_MNB12/0.0001-1e-9)))+(8.000000000999964e-07),0) m=M_MNB12*ceil(W_MNB12/0.0001-1e-9)
Mnb1 (NB0 NB0 VSS VSS) nmos1 w=(W_MNB12/ceil(W_MNB12/0.0001-1e-9)) l=L_MNB12 as=(4.000000000008894e-07*((W_MNB12/ceil(W_MNB12/0.0001-1e-9)))) ad=(4.000000000008894e-07*((W_MNB12/ceil(W_MNB12/0.0001-1e-9)))) ps=max(2*((W_MNB12/ceil(W_MNB12/0.0001-1e-9)))+(8.000000000999964e-07),0) pd=max(2*((W_MNB12/ceil(W_MNB12/0.0001-1e-9)))+(8.000000000999964e-07),0) m=M_MNB12*ceil(W_MNB12/0.0001-1e-9)
M4 (VDD N2 IN VSS) nmos1 w=(W_M4/ceil(W_M4/0.0001-1e-9)) l=L_M24 as=(3.999999999991146e-07*((W_M4/ceil(W_M4/0.0001-1e-9)))) ad=(3.999999999991146e-07*((W_M4/ceil(W_M4/0.0001-1e-9)))) ps=max(2*((W_M4/ceil(W_M4/0.0001-1e-9)))+(7.999999999000018e-07),0) pd=max(2*((W_M4/ceil(W_M4/0.0001-1e-9)))+(7.999999999000018e-07),0) m=M_M4*ceil(W_M4/0.0001-1e-9)
M2 (PLP N2 GND VSS) nmos1 w=(W_M2/ceil(W_M2/0.0001-1e-9)) l=L_M24 as=(4.0000000000000003e-07*((W_M2/ceil(W_M2/0.0001-1e-9)))) ad=(4.0000000000000003e-07*((W_M2/ceil(W_M2/0.0001-1e-9)))) ps=max(2*((W_M2/ceil(W_M2/0.0001-1e-9)))+(8.000000000000008e-07),0) pd=max(2*((W_M2/ceil(W_M2/0.0001-1e-9)))+(8.000000000000008e-07),0) m=M_M2*ceil(W_M2/0.0001-1e-9)
M1 (N2 N1 VSS VSS) nmos1 w=(W_M1/ceil(W_M1/0.0001-1e-9)) l=L_M1 as=(4e-07*((W_M1/ceil(W_M1/0.0001-1e-9)))) ad=(4e-07*((W_M1/ceil(W_M1/0.0001-1e-9)))) ps=max(2*((W_M1/ceil(W_M1/0.0001-1e-9)))+(8e-07),0) pd=max(2*((W_M1/ceil(W_M1/0.0001-1e-9)))+(8e-07),0) m=M_M1*ceil(W_M1/0.0001-1e-9)
I0 (GND NB0) isource dc=I0 type=dc
IB2 (PB2 GND) isource dc=IB2 type=dc
IB1 (PB1 GND) isource dc=IB1 type=dc
C2 (N2 GND) capacitor c=C2
C1 (N1 GND) capacitor c=C1
ends dtmos_candidate_stb
