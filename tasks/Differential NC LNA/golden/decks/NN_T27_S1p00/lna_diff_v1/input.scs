// analogiq 0.1.0 testbench - generated, do not edit
// task nclna02_task_001  topology nclna02_das_2021
// recipe lna_diff_v1 v1  condition NN_T27_S1p00 (models NN, 27 C, supply 1.5 V)
// request golden_nclna02_task_001  candidate e74c2c489772467e
// execution profile search_full
simulator lang=spectre
global 0
include "<CADENCE_SHARED>/FOUNDRY/analog/180nm/models/spectre/gpdk.scs" section=NN
include "dut.scs"

parameters vsup=1.5
// Sizing variables set in the testbench (external-bias values).
parameters V_BN=1.4585262402253565 V_BP=0.012143266419988507
// Supplies (charged to the DUT power metrics).
VSUP (vdd 0) vsource dc=vsup
// External bias (topology external_bias; reported separately as bias power).
VB_VSS (b_VSS 0) vsource dc=0.0
VB_Vbn (b_Vbn 0) vsource dc=V_BN
VB_Vbp (b_Vbp 0) vsource dc=V_BP

// Measurement instrumentation: single-ended port of 2*Z0 into an ideal balun (two 2:1 ideal
// transformers, centre tap at ground), ideal input DC blocks, open outputs with noiseless DC returns.
P1 (bal 0) port r=100.0 num=1 mag=1
TBP (bal 0 sbp 0) transformer n1=2 n2=1
TBN (bal 0 0 sbn) transformer n1=2 n2=1
CBIP (sbp rfin) capacitor c=1e-06
CBIN (sbn rfn) capacitor c=1e-06
RDCP (rfout 0) resistor r=1000000000.0 isnoisy=no
RDCN (rfoutn 0) resistor r=1000000000.0 isnoisy=no

XDUT (rfin rfn rfout rfoutn vdd b_VSS b_Vbn b_Vbp) nclna02_dut C_C=1.225229666597428e-11 C_O=7.901068780216291e-13 L_N=2.088273941383914e-07 L_P=1.8121143726786527e-07 N_N=44.0 N_P=4.0 R_C=52327.30503613221 R_L=789.5158568375299 W_N=4.821711347854466e-06 W_P=4.884543183008725e-05
op_info info what=oppoint where=rawfile

opts options temp=27.0 tnom=27 reltol=0.0001 save=selected
save VB_VSS:p VB_Vbn:p VB_Vbp:p VSUP:p rfin rfn rfout rfoutn vdd

op1 dc
sp1 sp start=10000000.0 stop=2000000000.0 dec=100 ports=[P1]
ac1 ac start=10000000.0 stop=2000000000.0 dec=100
nz1 (rfout rfoutn) noise start=10000000.0 stop=2000000000.0 dec=100 iprobe=P1
