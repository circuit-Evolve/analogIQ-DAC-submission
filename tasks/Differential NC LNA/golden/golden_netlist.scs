// Golden sizing netlist (curator 2026-10-28): the benchmark DUT subckt with its parameter defaults set to
// the golden design (golden_design.json), taken from the verified run's job NN_T27_S1p00/lna_diff_ip3_v1.
// The DUT subckt and its parameter values are the same in every job of that run (only the testbench changes).
// Instance line of that run: XDUT (rfin rfn rfout rfoutn vdd b_VSS b_Vbn b_Vbp) nclna02_dut C_C=1.225229666597428e-11 C_O=7.901068780216291e-13 L_N=2.088273941383914e-07 L_P=1.8121143726786527e-07 N_N=44.0 N_P=4.0 R_C=52327.30503...
// Testbench-level variables (bias sources, operating levels) are in golden_design.json and testbench decks.
// Generated by analogiq from final.scs (sha256 a099e2402584a1a3).
// Connectivity and device models are unchanged except for the listed transformations:
//   - symbols used but not declared in the netlist made DUT parameters: CL
//   - M1n: junction geometry as/ad/ps/pd rewritten in terms of the bound width (area = Lj*W, perimeter = 2*W + c; Lj and c from the netlist)
//   - M1p: junction geometry as/ad/ps/pd rewritten in terms of the bound width (area = Lj*W, perimeter = 2*W + c; Lj and c from the netlist)
//   - M2n: junction geometry as/ad/ps/pd rewritten in terms of the bound width (area = Lj*W, perimeter = 2*W + c; Lj and c from the netlist)
//   - M2p: junction geometry as/ad/ps/pd rewritten in terms of the bound width (area = Lj*W, perimeter = 2*W + c; Lj and c from the netlist)
//   - widths bound to sizing variables on fold-capable devices are folded symbolically into ceil(W/max) fingers of W/ceil(W/max) (per-device max [1e-05] m): M1n, M1p, M2n, M2p
subckt nclna02_dut (vip vin vop von VDD VSS Vbn Vbp)
parameters W_N=4.821711347854466e-06 L_N=2.088273941383914e-07 N_N=44.0 W_P=4.884543183008725e-05 L_P=1.8121143726786527e-07 N_P=4.0 C_C=1.225229666597428e-11 R_C=52327.30503613221 R_L=789.5158568375299 C_O=7.901068780216291e-13 CL=2e-13
CLn (von VSS) capacitor c=CL
CLp (vop VSS) capacitor c=CL
Cc1n (gn1 vin) capacitor c=C_C
Cc1p (gp1 vin) capacitor c=C_C
Cc2n (gn2 vip) capacitor c=C_C
Cc2p (gp2 vip) capacitor c=C_C
Co1n (dn1 vop) capacitor c=C_O
Co1p (vop dp1) capacitor c=C_O
Co2n (dn2 von) capacitor c=C_O
Co2p (von dp2) capacitor c=C_O
M1n (dn1 gn1 vip VSS) nmos1 w=(W_N/max(1, W_N/1e-05)) l=L_N m=N_N*max(1, W_N/1e-05) as=(6.000000000000001e-07*((W_N/max(1, W_N/1e-05)))) ad=(6.000000000000001e-07*((W_N/max(1, W_N/1e-05)))) ps=max(2*((W_N/max(1, W_N/1e-05)))+(1.200000000000002e-06),0) pd=max(2*((W_N/max(1, W_N/1e-05)))+(1.200000000000002e-06),0)
M1p (dp1 gp1 vip VDD) pmos1 w=(W_P/max(1, W_P/1e-05)) l=L_P m=N_P*max(1, W_P/1e-05) as=(3.9999999999999993e-07*((W_P/max(1, W_P/1e-05)))) ad=(3.9999999999999993e-07*((W_P/max(1, W_P/1e-05)))) ps=max(2*((W_P/max(1, W_P/1e-05)))+(-2.6266699999999997e-05),0) pd=max(2*((W_P/max(1, W_P/1e-05)))+(-2.6266699999999997e-05),0)
M2n (dn2 gn2 vin VSS) nmos1 w=(W_N/max(1, W_N/1e-05)) l=L_N m=N_N*max(1, W_N/1e-05) as=(6.000000000000001e-07*((W_N/max(1, W_N/1e-05)))) ad=(6.000000000000001e-07*((W_N/max(1, W_N/1e-05)))) ps=max(2*((W_N/max(1, W_N/1e-05)))+(1.200000000000002e-06),0) pd=max(2*((W_N/max(1, W_N/1e-05)))+(1.200000000000002e-06),0)
M2p (dp2 gp2 vin VDD) pmos1 w=(W_P/max(1, W_P/1e-05)) l=L_P m=N_P*max(1, W_P/1e-05) as=(3.9999999999999993e-07*((W_P/max(1, W_P/1e-05)))) ad=(3.9999999999999993e-07*((W_P/max(1, W_P/1e-05)))) ps=max(2*((W_P/max(1, W_P/1e-05)))+(-2.6266699999999997e-05),0) pd=max(2*((W_P/max(1, W_P/1e-05)))+(-2.6266699999999997e-05),0)
RL1n (VDD dn1) resistor r=R_L
RL1p (dp1 VSS) resistor r=R_L
RL2n (VDD dn2) resistor r=R_L
RL2p (dp2 VSS) resistor r=R_L
Rc1n (Vbn gn1) resistor r=R_C
Rc1p (gp1 Vbp) resistor r=R_C
Rc2n (Vbn gn2) resistor r=R_C
Rc2p (gp2 Vbp) resistor r=R_C
ends nclna02_dut
