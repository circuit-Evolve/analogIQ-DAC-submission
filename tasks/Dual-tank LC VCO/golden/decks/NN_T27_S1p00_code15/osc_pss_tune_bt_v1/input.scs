// analogiq 0.1.0 testbench - generated, do not edit
// task lcvco24_lohrabipour_task_001  topology lcvco24_lohrabipour
// recipe osc_pss_tune_bt_v1 v1  condition NN_T27_S1p00_code15 (models NN, 27 C, supply 0.85 V)
// request golden_lcvco24_lohrabipour_task_001  candidate 6bfcddeb36bf273d
// execution profile search_full
simulator lang=spectre
global 0
include "<CADENCE_SHARED>/FOUNDRY/analog/180nm/models/spectre/gpdk.scs" section=NN
include "dut.scs"

parameters cl=1e-14 vctrl=0.0 vsup=0.85
// Sizing variables set in the testbench (external-bias values).
parameters V_BUF=0.46518321942394436 V_TANK=0.755559630130096
// Supplies (charged to the DUT power metrics).
VSUP (vdd 0) vsource dc=vsup
// External bias (topology external_bias; reported separately as bias power).
VB_VSS (b_VSS 0) vsource dc=0.0
VB_VB_TANK (b_VB_TANK 0) vsource dc=V_TANK
VB_VDD_AUX (b_VDD_AUX 0) vsource dc=1.8
VB_VBUF (b_VBUF 0) vsource dc=V_BUF
VB_VDD_DIG (b_VDD_DIG 0) vsource dc=1.8
VB_S0 (b_S0 0) vsource dc=1.8
VB_S1 (b_S1 0) vsource dc=1.8
VB_S2 (b_S2 0) vsource dc=1.8
VB_S3 (b_S3 0) vsource dc=1.8

VCTRL (vctrl 0) vsource dc=vctrl
CL1 (outp 0) capacitor c=cl
CL2 (outn 0) capacitor c=cl
// Bias-T / 50 ohm instrument load on the open-drain buffer outputs.
RBT1 (b_VDD_AUX outp) resistor r=50.0
RBT2 (b_VDD_AUX outn) resistor r=50.0
// Start-up kick: current pulse into a DUT-internal (tank) node.
IKICK (0 XDUT.D1) isource type=pulse val0=0 val1=0.001 delay=0 rise=5.0000000000000005e-12 fall=5.0000000000000005e-12 width=5e-11

XDUT (vdd b_VSS b_VB_TANK b_VDD_AUX vctrl b_VBUF b_VDD_DIG b_S0 b_S1 b_S2 b_S3 outp outn) repaired_core C_BANK=1.501075231789765e-14 C_BUF=2.9548820937648065e-13 C_CVAR=1.9128351970037558e-11 C_PF=2.965502869235007e-12 C_PS=1.1647187503123352e-13 C_S=8.926770387630263e-11 L_BUF=2.3894281008286616e-07 L_CORE=6.64791039978928e-07 L_MIN=7.973475379935023e-07 L_MIP=2.360702088222717e-06 L_MS=1.0256710556367317e-06 L_MVAR=2.777200952474618e-06 L_P=1.0792078023030943e-10 L_S=1.95119356522058e-10 N_BUF=47.0 N_CORE=24.0 N_MIN=61.0 N_MIP=12.0 N_MS=55.0 N_MVAR=47.0 R_BUF=2559.742926900218 R_BVAR=451.40934361571084 R_SBANK=3489.283069631866 W_BUF=2.134373931502945e-05 W_CORE=3.0383214819168852e-05 W_MIN=7.798150060332384e-07 W_MIP=1.1595077309896755e-05 W_MS=4.600458796649638e-05 W_MVAR=7.986241272516669e-07

opts options temp=27.0 tnom=27 reltol=0.0001 save=selected
save VB_S0:p VB_S1:p VB_S2:p VB_S3:p VB_VBUF:p VB_VB_TANK:p VB_VDD_AUX:p VB_VDD_DIG:p VB_VSS:p VSUP:p outn outp vctrl vdd

// osc_sweep_begin (replaced by OscPssTune.prepare when the task has an `estimate` setting)
sw sweep param=vctrl values=[0.0 0.3 0.6 0.9 1.2] {
pss1 (outp outn) pss fund=5080000000.0 harms=10 tstab=3e-08 errpreset=conservative
pn1 (outp outn) pnoise start=50000.0 stop=20000000.0 dec=10 maxsideband=10 sweeptype=relative relharmnum=1 noisetype=timeaverage
}
// osc_sweep_end
