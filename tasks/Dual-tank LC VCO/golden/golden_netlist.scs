// Golden sizing netlist (curator 2026-10-28): the benchmark DUT subckt with its parameter defaults set to
// the golden design (golden_design.json), taken from the verified run's job NN_T27_S1p00/osc_dc_bt_v1.
// The DUT subckt and its parameter values are the same in every job of that run (only the testbench changes).
// Instance line of that run: XDUT (vdd b_VSS b_VB_TANK b_VDD_AUX vctrl b_VBUF b_VDD_DIG b_S0 b_S1 b_S2 b_S3 outp outn) repaired_core C_BANK=1.501075231789765e-14 C_BUF=2.9548820937648065e-13 C_CVAR=1.9128351970037558e-11 C_PF=2.9...
// Testbench-level variables (bias sources, operating levels) are in golden_design.json and testbench decks.
// Generated by analogiq from dut_benchmark.scs (sha256 5d4b7e56392b039d).
// Connectivity and device models are unchanged except for the listed transformations:
//   - M2: junction geometry ad/as/pd/ps rewritten in terms of the bound width (area = Lj*W, perimeter = 2*W + c; Lj and c from the netlist)
//   - M1: junction geometry ad/as/pd/ps rewritten in terms of the bound width (area = Lj*W, perimeter = 2*W + c; Lj and c from the netlist)
//   - MBUFL: junction geometry ad/as/pd/ps rewritten in terms of the bound width (area = Lj*W, perimeter = 2*W + c; Lj and c from the netlist)
//   - MBUFR: junction geometry ad/as/pd/ps rewritten in terms of the bound width (area = Lj*W, perimeter = 2*W + c; Lj and c from the netlist)
//   - MIN0: junction geometry ad/as/pd/ps rewritten in terms of the bound width (area = Lj*W, perimeter = 2*W + c; Lj and c from the netlist)
//   - MIP0: junction geometry ad/as/pd/ps rewritten in terms of the bound width (area = Lj*W, perimeter = 2*W + c; Lj and c from the netlist)
//   - MS0L: junction geometry ad/as/pd/ps rewritten in terms of the bound width (area = Lj*W, perimeter = 2*W + c; Lj and c from the netlist)
//   - MS0R: junction geometry ad/as/pd/ps rewritten in terms of the bound width (area = Lj*W, perimeter = 2*W + c; Lj and c from the netlist)
//   - MIN1: junction geometry ad/as/pd/ps rewritten in terms of the bound width (area = Lj*W, perimeter = 2*W + c; Lj and c from the netlist)
//   - MIP1: junction geometry ad/as/pd/ps rewritten in terms of the bound width (area = Lj*W, perimeter = 2*W + c; Lj and c from the netlist)
//   - MS1L: junction geometry ad/as/pd/ps rewritten in terms of the bound width (area = Lj*W, perimeter = 2*W + c; Lj and c from the netlist)
//   - MS1R: junction geometry ad/as/pd/ps rewritten in terms of the bound width (area = Lj*W, perimeter = 2*W + c; Lj and c from the netlist)
//   - MIN2: junction geometry ad/as/pd/ps rewritten in terms of the bound width (area = Lj*W, perimeter = 2*W + c; Lj and c from the netlist)
//   - MIP2: junction geometry ad/as/pd/ps rewritten in terms of the bound width (area = Lj*W, perimeter = 2*W + c; Lj and c from the netlist)
//   - MS2L: junction geometry ad/as/pd/ps rewritten in terms of the bound width (area = Lj*W, perimeter = 2*W + c; Lj and c from the netlist)
//   - MS2R: junction geometry ad/as/pd/ps rewritten in terms of the bound width (area = Lj*W, perimeter = 2*W + c; Lj and c from the netlist)
//   - MIN3: junction geometry ad/as/pd/ps rewritten in terms of the bound width (area = Lj*W, perimeter = 2*W + c; Lj and c from the netlist)
//   - MIP3: junction geometry ad/as/pd/ps rewritten in terms of the bound width (area = Lj*W, perimeter = 2*W + c; Lj and c from the netlist)
//   - MS3L: junction geometry ad/as/pd/ps rewritten in terms of the bound width (area = Lj*W, perimeter = 2*W + c; Lj and c from the netlist)
//   - MS3R: junction geometry ad/as/pd/ps rewritten in terms of the bound width (area = Lj*W, perimeter = 2*W + c; Lj and c from the netlist)
//   - widths bound to sizing variables on fold-capable devices are folded symbolically into ceil(W/max) fingers of W/ceil(W/max) (per-device max [1e-05] m): M1, M2, MBUFL, MBUFR, MIN0, MIN1, MIN2, MIN3, MIP0, MIP1, MIP2, MIP3, MS0L, MS0R, MS1L, MS1R, MS2L, MS2R, MS3L, MS3R, MVARL, MVARR
//   - junction geometry not in the netlist, derived from W per the technology rule {'nmos1': {'as': 'w*6e-07', 'ad': 'w*6e-07', 'ps': 'w+1.2e-06', 'pd': 'w+1.2e-06'}, 'pmos1': {'as': 'w*6e-07', 'ad': 'w*6e-07', 'ps': 'w+1.2e-06', 'pd': 'w+1.2e-06'}, 'nmos25': {'as': 'w*6e-07', 'ad': 'w*6e-07', 'ps': 'w+1.2e-06', 'pd': 'w+1.2e-06'}, 'pmos25': {'as': 'w*6e-07', 'ad': 'w*6e-07', 'ps': 'w+1.2e-06', 'pd': 'w+1.2e-06'}} for: MVARL, MVARR
subckt repaired_core (VDD_CORE VSS VB_TANK VDD_AUX VC VBUF VDD_DIG S0 S1 S2 S3 RFL RFR)
parameters N_CORE=24.0 W_CORE=3.0383214819168852e-05 L_CORE=6.64791039978928e-07 N_MVAR=47.0 W_MVAR=7.986241272516669e-07 L_MVAR=2.777200952474618e-06 N_BUF=47.0 W_BUF=2.134373931502945e-05 L_BUF=2.3894281008286616e-07 N_MIN=61.0 W_MIN=7.798150060332384e-07 L_MIN=7.973475379935023e-07 N_MIP=12.0 W_MIP=1.1595077309896755e-05 L_MIP=2.360702088222717e-06 N_MS=55.0 W_MS=4.600458796649638e-05 L_MS=1.0256710556367317e-06 C_S=8.926770387630263e-11 C_PF=2.965502869235007e-12 C_PS=1.1647187503123352e-13 L_P=1.0792078023030943e-10 L_S=1.95119356522058e-10 C_CVAR=1.9128351970037558e-11 R_BVAR=451.40934361571084 C_BUF=2.9548820937648065e-13 R_BUF=2559.742926900218 C_BANK=1.501075231789765e-14 R_SBANK=3489.283069631866
M2 (D2 G2 VSS VSS) nmos1 w=(W_CORE/max(1, W_CORE/1e-05)) l=L_CORE m=N_CORE*max(1, W_CORE/1e-05) ad=(3.0000000000000004e-07*((W_CORE/max(1, W_CORE/1e-05)))) as=(6.000000000000001e-07*((W_CORE/max(1, W_CORE/1e-05)))) pd=max(2*((W_CORE/max(1, W_CORE/1e-05)))+(-3.7399999999999994e-05),0) ps=max(2*((W_CORE/max(1, W_CORE/1e-05)))+(1.200000000000002e-06),0)
M1 (D1 G1 VSS VSS) nmos1 w=(W_CORE/max(1, W_CORE/1e-05)) l=L_CORE m=N_CORE*max(1, W_CORE/1e-05) ad=(3.0000000000000004e-07*((W_CORE/max(1, W_CORE/1e-05)))) as=(6.000000000000001e-07*((W_CORE/max(1, W_CORE/1e-05)))) pd=max(2*((W_CORE/max(1, W_CORE/1e-05)))+(-3.7399999999999994e-05),0) ps=max(2*((W_CORE/max(1, W_CORE/1e-05)))+(1.200000000000002e-06),0)
CSL (D2 G1) capacitor c=C_S
CSR (D1 G2) capacitor c=C_S
CPFL (D2 CPF_MID) capacitor c=C_PF
CPFR (CPF_MID D1) capacitor c=C_PF
CPSL (D2 VSS) capacitor c=C_PS
CPSR (D1 VSS) capacitor c=C_PS
LPL (D2 XPL) inductor l=L_P
RPL (XPL VDD_CORE) resistor r=(2*3.14159265*5.08e9*L_P/17.4)
LPR (VDD_CORE XPR) inductor l=L_P
RPR (XPR D1) resistor r=(2*3.14159265*5.08e9*L_P/17.4)
LSL (G1 XSL) inductor l=L_S
RSL (XSL VB_TANK) resistor r=(2*3.14159265*5.08e9*L_S/16.7)
LSR (VB_TANK XSR) inductor l=L_S
RSR (XSR G2) resistor r=(2*3.14159265*5.08e9*L_S/16.7)
KL () mutual_inductor ind1=LPL ind2=LSL k=.41
KR () mutual_inductor ind1=LPR ind2=LSR k=.41
CCVARL (D2 VARL) capacitor c=C_CVAR
MVARL (VC VARL VC VC) pmos1 w=(W_MVAR/max(1, W_MVAR/1e-05)) l=L_MVAR m=N_MVAR*max(1, W_MVAR/1e-05) as=(((W_MVAR/max(1, W_MVAR/1e-05)))*6e-07) ad=(((W_MVAR/max(1, W_MVAR/1e-05)))*6e-07) ps=(((W_MVAR/max(1, W_MVAR/1e-05)))+1.2e-06) pd=(((W_MVAR/max(1, W_MVAR/1e-05)))+1.2e-06)
RBVARL (VDD_AUX VARL) resistor r=R_BVAR
MBUFL (RFL BUFGL VSS VSS) nmos1 w=(W_BUF/max(1, W_BUF/1e-05)) l=L_BUF m=N_BUF*max(1, W_BUF/1e-05) ad=(6.000000000000001e-07*((W_BUF/max(1, W_BUF/1e-05)))) as=(6.000000000000001e-07*((W_BUF/max(1, W_BUF/1e-05)))) pd=max(2*((W_BUF/max(1, W_BUF/1e-05)))+(-4.899999999999999e-05),0) ps=max(2*((W_BUF/max(1, W_BUF/1e-05)))+(-4.899999999999999e-05),0)
CBUFL (D2 BUFGL) capacitor c=C_BUF
RBUFL (VBUF BUFGL) resistor r=R_BUF
CCVARR (D1 VARR) capacitor c=C_CVAR
MVARR (VC VARR VC VC) pmos1 w=(W_MVAR/max(1, W_MVAR/1e-05)) l=L_MVAR m=N_MVAR*max(1, W_MVAR/1e-05) as=(((W_MVAR/max(1, W_MVAR/1e-05)))*6e-07) ad=(((W_MVAR/max(1, W_MVAR/1e-05)))*6e-07) ps=(((W_MVAR/max(1, W_MVAR/1e-05)))+1.2e-06) pd=(((W_MVAR/max(1, W_MVAR/1e-05)))+1.2e-06)
RBVARR (VDD_AUX VARR) resistor r=R_BVAR
MBUFR (RFR BUFGR VSS VSS) nmos1 w=(W_BUF/max(1, W_BUF/1e-05)) l=L_BUF m=N_BUF*max(1, W_BUF/1e-05) ad=(6.000000000000001e-07*((W_BUF/max(1, W_BUF/1e-05)))) as=(6.000000000000001e-07*((W_BUF/max(1, W_BUF/1e-05)))) pd=max(2*((W_BUF/max(1, W_BUF/1e-05)))+(-4.899999999999999e-05),0) ps=max(2*((W_BUF/max(1, W_BUF/1e-05)))+(-4.899999999999999e-05),0)
CBUFR (D1 BUFGR) capacitor c=C_BUF
RBUFR (VBUF BUFGR) resistor r=R_BUF
MIN0 (SB0 S0 VSS VSS) nmos1 w=(W_MIN/max(1, W_MIN/1e-05)) l=L_MIN m=N_MIN*max(1, W_MIN/1e-05) ad=(6.000000000000001e-07*((W_MIN/max(1, W_MIN/1e-05)))) as=(6.000000000000001e-07*((W_MIN/max(1, W_MIN/1e-05)))) pd=max(2*((W_MIN/max(1, W_MIN/1e-05)))+(-8.999999999999999e-06),0) ps=max(2*((W_MIN/max(1, W_MIN/1e-05)))+(-8.999999999999999e-06),0)
MIP0 (SB0 S0 VDD_DIG VDD_DIG) pmos1 w=(W_MIP/max(1, W_MIP/1e-05)) l=L_MIP m=N_MIP*max(1, W_MIP/1e-05) ad=(6.000000000000001e-07*((W_MIP/max(1, W_MIP/1e-05)))) as=(6.000000000000001e-07*((W_MIP/max(1, W_MIP/1e-05)))) pd=max(2*((W_MIP/max(1, W_MIP/1e-05)))+(-1.8999999999999998e-05),0) ps=max(2*((W_MIP/max(1, W_MIP/1e-05)))+(-1.8999999999999998e-05),0)
MS0L (BANK0L S0 VSS VSS) nmos1 w=(W_MS/max(1, W_MS/1e-05)) l=L_MS m=N_MS*max(1, W_MS/1e-05) ad=(6.000000000000001e-07*((W_MS/max(1, W_MS/1e-05)))) as=(6.000000000000001e-07*((W_MS/max(1, W_MS/1e-05)))) pd=max(2*((W_MS/max(1, W_MS/1e-05)))+(-9.899999999999998e-05),0) ps=max(2*((W_MS/max(1, W_MS/1e-05)))+(-9.899999999999998e-05),0)
CB0L (D2 BANK0L) capacitor c=C_BANK
RS0L (SB0 BANK0L) resistor r=R_SBANK
MS0R (BANK0R S0 VSS VSS) nmos1 w=(W_MS/max(1, W_MS/1e-05)) l=L_MS m=N_MS*max(1, W_MS/1e-05) ad=(6.000000000000001e-07*((W_MS/max(1, W_MS/1e-05)))) as=(6.000000000000001e-07*((W_MS/max(1, W_MS/1e-05)))) pd=max(2*((W_MS/max(1, W_MS/1e-05)))+(-9.899999999999998e-05),0) ps=max(2*((W_MS/max(1, W_MS/1e-05)))+(-9.899999999999998e-05),0)
CB0R (D1 BANK0R) capacitor c=C_BANK
RS0R (SB0 BANK0R) resistor r=R_SBANK
MIN1 (SB1 S1 VSS VSS) nmos1 w=(W_MIN/max(1, W_MIN/1e-05)) l=L_MIN m=N_MIN*max(1, W_MIN/1e-05) ad=(6.000000000000001e-07*((W_MIN/max(1, W_MIN/1e-05)))) as=(6.000000000000001e-07*((W_MIN/max(1, W_MIN/1e-05)))) pd=max(2*((W_MIN/max(1, W_MIN/1e-05)))+(-8.999999999999999e-06),0) ps=max(2*((W_MIN/max(1, W_MIN/1e-05)))+(-8.999999999999999e-06),0)
MIP1 (SB1 S1 VDD_DIG VDD_DIG) pmos1 w=(W_MIP/max(1, W_MIP/1e-05)) l=L_MIP m=N_MIP*max(1, W_MIP/1e-05) ad=(6.000000000000001e-07*((W_MIP/max(1, W_MIP/1e-05)))) as=(6.000000000000001e-07*((W_MIP/max(1, W_MIP/1e-05)))) pd=max(2*((W_MIP/max(1, W_MIP/1e-05)))+(-1.8999999999999998e-05),0) ps=max(2*((W_MIP/max(1, W_MIP/1e-05)))+(-1.8999999999999998e-05),0)
MS1L (BANK1L S1 VSS VSS) nmos1 w=(W_MS/max(1, W_MS/1e-05)) l=L_MS m=N_MS*max(1, W_MS/1e-05) ad=(6.000000000000001e-07*((W_MS/max(1, W_MS/1e-05)))) as=(6.000000000000001e-07*((W_MS/max(1, W_MS/1e-05)))) pd=max(2*((W_MS/max(1, W_MS/1e-05)))+(-9.899999999999998e-05),0) ps=max(2*((W_MS/max(1, W_MS/1e-05)))+(-9.899999999999998e-05),0)
CB1L (D2 BANK1L) capacitor c=(2*C_BANK)
RS1L (SB1 BANK1L) resistor r=R_SBANK
MS1R (BANK1R S1 VSS VSS) nmos1 w=(W_MS/max(1, W_MS/1e-05)) l=L_MS m=N_MS*max(1, W_MS/1e-05) ad=(6.000000000000001e-07*((W_MS/max(1, W_MS/1e-05)))) as=(6.000000000000001e-07*((W_MS/max(1, W_MS/1e-05)))) pd=max(2*((W_MS/max(1, W_MS/1e-05)))+(-9.899999999999998e-05),0) ps=max(2*((W_MS/max(1, W_MS/1e-05)))+(-9.899999999999998e-05),0)
CB1R (D1 BANK1R) capacitor c=(2*C_BANK)
RS1R (SB1 BANK1R) resistor r=R_SBANK
MIN2 (SB2 S2 VSS VSS) nmos1 w=(W_MIN/max(1, W_MIN/1e-05)) l=L_MIN m=N_MIN*max(1, W_MIN/1e-05) ad=(6.000000000000001e-07*((W_MIN/max(1, W_MIN/1e-05)))) as=(6.000000000000001e-07*((W_MIN/max(1, W_MIN/1e-05)))) pd=max(2*((W_MIN/max(1, W_MIN/1e-05)))+(-8.999999999999999e-06),0) ps=max(2*((W_MIN/max(1, W_MIN/1e-05)))+(-8.999999999999999e-06),0)
MIP2 (SB2 S2 VDD_DIG VDD_DIG) pmos1 w=(W_MIP/max(1, W_MIP/1e-05)) l=L_MIP m=N_MIP*max(1, W_MIP/1e-05) ad=(6.000000000000001e-07*((W_MIP/max(1, W_MIP/1e-05)))) as=(6.000000000000001e-07*((W_MIP/max(1, W_MIP/1e-05)))) pd=max(2*((W_MIP/max(1, W_MIP/1e-05)))+(-1.8999999999999998e-05),0) ps=max(2*((W_MIP/max(1, W_MIP/1e-05)))+(-1.8999999999999998e-05),0)
MS2L (BANK2L S2 VSS VSS) nmos1 w=(W_MS/max(1, W_MS/1e-05)) l=L_MS m=N_MS*max(1, W_MS/1e-05) ad=(6.000000000000001e-07*((W_MS/max(1, W_MS/1e-05)))) as=(6.000000000000001e-07*((W_MS/max(1, W_MS/1e-05)))) pd=max(2*((W_MS/max(1, W_MS/1e-05)))+(-9.899999999999998e-05),0) ps=max(2*((W_MS/max(1, W_MS/1e-05)))+(-9.899999999999998e-05),0)
CB2L (D2 BANK2L) capacitor c=(4*C_BANK)
RS2L (SB2 BANK2L) resistor r=R_SBANK
MS2R (BANK2R S2 VSS VSS) nmos1 w=(W_MS/max(1, W_MS/1e-05)) l=L_MS m=N_MS*max(1, W_MS/1e-05) ad=(6.000000000000001e-07*((W_MS/max(1, W_MS/1e-05)))) as=(6.000000000000001e-07*((W_MS/max(1, W_MS/1e-05)))) pd=max(2*((W_MS/max(1, W_MS/1e-05)))+(-9.899999999999998e-05),0) ps=max(2*((W_MS/max(1, W_MS/1e-05)))+(-9.899999999999998e-05),0)
CB2R (D1 BANK2R) capacitor c=(4*C_BANK)
RS2R (SB2 BANK2R) resistor r=R_SBANK
MIN3 (SB3 S3 VSS VSS) nmos1 w=(W_MIN/max(1, W_MIN/1e-05)) l=L_MIN m=N_MIN*max(1, W_MIN/1e-05) ad=(6.000000000000001e-07*((W_MIN/max(1, W_MIN/1e-05)))) as=(6.000000000000001e-07*((W_MIN/max(1, W_MIN/1e-05)))) pd=max(2*((W_MIN/max(1, W_MIN/1e-05)))+(-8.999999999999999e-06),0) ps=max(2*((W_MIN/max(1, W_MIN/1e-05)))+(-8.999999999999999e-06),0)
MIP3 (SB3 S3 VDD_DIG VDD_DIG) pmos1 w=(W_MIP/max(1, W_MIP/1e-05)) l=L_MIP m=N_MIP*max(1, W_MIP/1e-05) ad=(6.000000000000001e-07*((W_MIP/max(1, W_MIP/1e-05)))) as=(6.000000000000001e-07*((W_MIP/max(1, W_MIP/1e-05)))) pd=max(2*((W_MIP/max(1, W_MIP/1e-05)))+(-1.8999999999999998e-05),0) ps=max(2*((W_MIP/max(1, W_MIP/1e-05)))+(-1.8999999999999998e-05),0)
MS3L (BANK3L S3 VSS VSS) nmos1 w=(W_MS/max(1, W_MS/1e-05)) l=L_MS m=N_MS*max(1, W_MS/1e-05) ad=(6.000000000000001e-07*((W_MS/max(1, W_MS/1e-05)))) as=(6.000000000000001e-07*((W_MS/max(1, W_MS/1e-05)))) pd=max(2*((W_MS/max(1, W_MS/1e-05)))+(-9.899999999999998e-05),0) ps=max(2*((W_MS/max(1, W_MS/1e-05)))+(-9.899999999999998e-05),0)
CB3L (D2 BANK3L) capacitor c=(8*C_BANK)
RS3L (SB3 BANK3L) resistor r=R_SBANK
MS3R (BANK3R S3 VSS VSS) nmos1 w=(W_MS/max(1, W_MS/1e-05)) l=L_MS m=N_MS*max(1, W_MS/1e-05) ad=(6.000000000000001e-07*((W_MS/max(1, W_MS/1e-05)))) as=(6.000000000000001e-07*((W_MS/max(1, W_MS/1e-05)))) pd=max(2*((W_MS/max(1, W_MS/1e-05)))+(-9.899999999999998e-05),0) ps=max(2*((W_MS/max(1, W_MS/1e-05)))+(-9.899999999999998e-05),0)
CB3R (D1 BANK3R) capacitor c=(8*C_BANK)
RS3R (SB3 BANK3R) resistor r=R_SBANK
ends repaired_core
