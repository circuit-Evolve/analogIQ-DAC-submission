// Design: test/LDO_with_erroramp_tb_dac
simulator lang=spectre
global 0
parameters i_load=25m
include "<PDK_ROOT>/gpdk045_v_5_0/models/spectre/gpdk045.scs" section=ff

// test/LDO_with_erroramp/schematic_golden
include "dut.scs"

// test/LDO_with_erroramp_tb_dac/schematic
I7 (VOUT 0) bsource i=i_load*0.5*(1+tanh((v(VOUT)-100m)/20m))
C0 (VOUT 0) capacitor c=100p
V0 (net2 0) vsource dc=1.8 mag=1 phase=0 type=sine
V1 (net3 0) vsource dc=600.0m type=sine
I8 (net2 net2 VOUT net3 0) LDO_with_erroramp
simulatorOptions options reltol=1e-6 vabstol=1e-9 temp=125
stb stb start=0.1 stop=1G dec=100 probe=I8.IPRB0
tran tran stop=1
ac ac start=1 stop=100M dec=100
dcOp dc
dc dc param=i_load start=0 stop=50m
extremeinfo info what=all where=logfile extremes=yes
allcap info what=allcap where=file
simStatistics info what=simstat where=rawfile
saveOptions options save=all pwr=all currents=all useprobes=yes saveahdlvars=all
