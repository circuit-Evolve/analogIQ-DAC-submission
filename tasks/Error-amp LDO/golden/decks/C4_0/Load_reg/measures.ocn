opened=errset(openResults("raw") t)
fp=outfile("scalars.tsv")
v=nil
when(opened && car(opened) v=errset(phaseMargin((- getData("loopGain" ?result "stb"))) t))
if(v && numberp(car(v)) then fprintf(fp "5\t%.16g\n" car(v)) else fprintf(fp "5\tERROR\n"))
v=nil
when(opened && car(opened) v=errset(cross(mag(getData("loopGain" ?result "stb")) 1 1 "falling") t))
if(v && numberp(car(v)) then fprintf(fp "6\t%.16g\n" car(v)) else fprintf(fp "6\tERROR\n"))
v=nil
when(opened && car(opened) v=errset(value(dB20((getData("net2" ?result "ac") / getData("VOUT" ?result "ac"))) 100) t))
if(v && numberp(car(v)) then fprintf(fp "7\t%.16g\n" car(v)) else fprintf(fp "7\tERROR\n"))
v=nil
when(opened && car(opened) v=errset(value(dB20((getData("net2" ?result "ac") / getData("VOUT" ?result "ac"))) 1000000) t))
if(v && numberp(car(v)) then fprintf(fp "8\t%.16g\n" car(v)) else fprintf(fp "8\tERROR\n"))
v=nil
when(opened && car(opened) v=errset(abs(((1000 * peakToPeak(getData("VOUT" ?result "dc"))) / 0.05)) t))
if(v && numberp(car(v)) then fprintf(fp "9\t%.16g\n" car(v)) else fprintf(fp "9\tERROR\n"))
v=nil
when(opened && car(opened) v=errset(average(getData("VOUT" ?result "tran")) t))
if(v && numberp(car(v)) then fprintf(fp "10\t%.16g\n" car(v)) else fprintf(fp "10\tERROR\n"))
close(fp)
exit()
