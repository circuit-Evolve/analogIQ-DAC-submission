// Design: test/LDO_with_erroramp_tb_dac
simulator lang=spectre
global 0
parameters i_load=25m
include "<PDK_ROOT>/gpdk045_v_5_0/models/spectre/gpdk045.scs" section=tt

// test/LDO_with_erroramp/schematic_golden
simulator lang=spectre
subckt LDO_with_erroramp VDD_core VIN VOUT VREF gnd
    I0 (VDD_core net3) isource dc=(25u) type=dc
    M10 (VOUT net13 VIN VIN) g45p2svt w=(350u) l=(150n) nf=(35) m=(1)
    M14 (VOUT net13 VIN VIN) g45p2svt w=(350u) l=(150n) nf=(35) m=(1)
    M12 (VOUT net13 VIN VIN) g45p2svt w=(350u) l=(150n) nf=(35) m=(1)
    M13 (VOUT net13 VIN VIN) g45p2svt w=(350u) l=(150n) nf=(35) m=(1)
    M11 (VOUT net13 VIN VIN) g45p2svt w=(350u) l=(150n) nf=(35) m=(1)
    M9 (net12 net11 net10 VIN) g45p2svt w=(3u) l=(150n) nf=(1) m=(2)
    C2 (net4 net11) capacitor c=(12p)
    C0 (net13 net12) capacitor c=(10p)
    C1 (VOUT net6) capacitor c=(50p)
    M5 (net1 net2 VDD_core VDD_core) g45p1svt w=(6u) l=(500n) nf=(1) m=(3)
    M6 (net2 net2 VDD_core VDD_core) g45p1svt w=(6u) l=(500n) nf=(1) m=(3)
    M7 (net11 net1 VDD_core VDD_core) g45p1svt w=(250u) l=(180n) nf=(25) m=(1)
    M0 (net3 net3 gnd gnd) g45n1svt w=(4u) l=(1u) nf=(1) m=(6)
    M1 (net5 net3 gnd gnd) g45n1svt w=(4u) l=(1u) nf=(1) m=(6)
    M2 (net1 VREF net5 gnd) g45n1svt w=(4u) l=(1u) nf=(1) m=(6)
    M3 (net11 net3 gnd gnd) g45n1svt w=(50u) l=(1u) nf=(5) m=(6)
    M4 (net2 net7 net5 gnd) g45n1svt w=(4u) l=(1u) nf=(1) m=(6)
    IPRB0 (net7 net6) iprobe
    R10 (VIN net10) resistor r=(150)
    R9 (net13 net12) resistor r=(10k)
    R8 (net6 gnd) resistor r=(50)
    R7 (net12 gnd) resistor r=(16700)
    R11 (VOUT net6) resistor r=(50)
    R0 (net4 net1) resistor r=(2700)
ends LDO_with_erroramp

// test/LDO_with_erroramp_tb_dac/schematic
I7 (VOUT 0) bsource i=i_load*0.5*(1+tanh((v(VOUT)-100m)/20m))
C0 (VOUT 0) capacitor c=100p
V0 (net2 0) vsource dc=1.8 mag=1 phase=0 type=sine
V1 (net3 0) vsource dc=600.0m type=sine
I8 (net2 net2 VOUT net3 0) LDO_with_erroramp
simulatorOptions options reltol=1e-6 vabstol=1e-9 temp=27
stb stb start=0.1 stop=1G dec=100 probe=I8.IPRB0
tran tran stop=1
ac ac start=1 stop=100M dec=100
dcOp dc
dc dc param=i_load start=0 stop=50m
extremeinfo info what=all where=logfile extremes=yes
allcap info what=allcap where=file
simStatistics info what=simstat where=rawfile
saveOptions options save=all pwr=all currents=all useprobes=yes saveahdlvars=all
