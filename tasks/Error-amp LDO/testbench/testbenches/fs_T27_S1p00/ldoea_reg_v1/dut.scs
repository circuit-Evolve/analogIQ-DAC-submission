// Generated by analogiq from dut_benchmark.scs (sha256 ef3e6a473737014b).
// Connectivity and device models are unchanged except for the listed transformations:
//   - ideal elements kept inside the DUT: I0
//   - M10: junction geometry as/ad/ps/pd/nrd/nrs rewritten in terms of the bound width (area = Lj*W, perimeter = 2*W + c; Lj and c from the netlist); diffusion squares nrd/nrs = NR0*W0/W
//   - M14: junction geometry as/ad/ps/pd/nrd/nrs rewritten in terms of the bound width (area = Lj*W, perimeter = 2*W + c; Lj and c from the netlist); diffusion squares nrd/nrs = NR0*W0/W
//   - M12: junction geometry as/ad/ps/pd/nrd/nrs rewritten in terms of the bound width (area = Lj*W, perimeter = 2*W + c; Lj and c from the netlist); diffusion squares nrd/nrs = NR0*W0/W
//   - M13: junction geometry as/ad/ps/pd/nrd/nrs rewritten in terms of the bound width (area = Lj*W, perimeter = 2*W + c; Lj and c from the netlist); diffusion squares nrd/nrs = NR0*W0/W
//   - M11: junction geometry as/ad/ps/pd/nrd/nrs rewritten in terms of the bound width (area = Lj*W, perimeter = 2*W + c; Lj and c from the netlist); diffusion squares nrd/nrs = NR0*W0/W
//   - M9: junction geometry as/ad/ps/pd/nrd/nrs rewritten in terms of the bound width (area = Lj*W, perimeter = 2*W + c; Lj and c from the netlist); diffusion squares nrd/nrs = NR0*W0/W
//   - M5: junction geometry as/ad/ps/pd/nrd/nrs rewritten in terms of the bound width (area = Lj*W, perimeter = 2*W + c; Lj and c from the netlist); diffusion squares nrd/nrs = NR0*W0/W
//   - M6: junction geometry as/ad/ps/pd/nrd/nrs rewritten in terms of the bound width (area = Lj*W, perimeter = 2*W + c; Lj and c from the netlist); diffusion squares nrd/nrs = NR0*W0/W
//   - M7: junction geometry as/ad/ps/pd/nrd/nrs rewritten in terms of the bound width (area = Lj*W, perimeter = 2*W + c; Lj and c from the netlist); diffusion squares nrd/nrs = NR0*W0/W
//   - M0: junction geometry as/ad/ps/pd/nrd/nrs rewritten in terms of the bound width (area = Lj*W, perimeter = 2*W + c; Lj and c from the netlist); diffusion squares nrd/nrs = NR0*W0/W
//   - M1: junction geometry as/ad/ps/pd/nrd/nrs rewritten in terms of the bound width (area = Lj*W, perimeter = 2*W + c; Lj and c from the netlist); diffusion squares nrd/nrs = NR0*W0/W
//   - M2: junction geometry as/ad/ps/pd/nrd/nrs rewritten in terms of the bound width (area = Lj*W, perimeter = 2*W + c; Lj and c from the netlist); diffusion squares nrd/nrs = NR0*W0/W
//   - M3: junction geometry as/ad/ps/pd/nrd/nrs rewritten in terms of the bound width (area = Lj*W, perimeter = 2*W + c; Lj and c from the netlist); diffusion squares nrd/nrs = NR0*W0/W
//   - M4: junction geometry as/ad/ps/pd/nrd/nrs rewritten in terms of the bound width (area = Lj*W, perimeter = 2*W + c; Lj and c from the netlist); diffusion squares nrd/nrs = NR0*W0/W
//   - loop-break iprobe IPRB_LOOP inserted between net net6 and terminal 1 of M4
//   - netlist parameters bound to sizing variables: W_BUF <- W_BUF, W_CS2 <- W_CS2, W_IN <- W_IN, W_LD <- W_LD, W_MIR <- W_MIR, W_PASS <- W_PASS, W_SNK <- W_SNK
subckt ldo_erroramp_dac_dut (VDD_core VIN VOUT VREF gnd)
parameters W_PASS=1e-06 L_PASS=1e-06 NF_PASS=1.0 W_BUF=1e-06 L_BUF=1e-06 NF_BUF=1.0 M_BUF=1.0 W_IN=1e-06 L_IN=1e-06 NF_IN=1.0 M_IN=1.0 W_LD=1e-06 L_LD=1e-06 NF_LD=1.0 M_LD=1.0 W_CS2=1e-06 L_CS2=1e-06 NF_CS2=1.0 W_MIR=1e-06 L_MIR=1e-06 NF_MIR=1.0 M_MIR=1.0 W_SNK=1e-06 NF_SNK=1.0 M_SNK=1.0 C_C=1e-12 R_Z=10000.0 C_G=1e-12 R_G=10000.0 C_FF=1e-12 R_S=10000.0 R_B=10000.0 R_FB_TOP=10000.0 R_FB_BOT=10000.0 I_BIAS=1e-05 M_PASS=1.0 M_CS2=1.0
I0 (VDD_core net3) isource dc=I_BIAS type=dc
M10 (VOUT net13 VIN VIN) g45p2svt w=(W_PASS*NF_PASS) l=L_PASS nf=NF_PASS as=(1.0142857142857143e-07*((W_PASS*NF_PASS))) ad=(1.0142857142857143e-07*((W_PASS*NF_PASS))) ps=max(2*((W_PASS*NF_PASS))+(-0.00033289999999999996),0) pd=max(2*((W_PASS*NF_PASS))+(-0.00033289999999999996),0) nrd=(1.0142859999999999e-07/((W_PASS*NF_PASS))) nrs=(1.0142859999999999e-07/((W_PASS*NF_PASS))) sa=150n sb=150n sd=200n sca=10.31048 scb=0.00999 scc=0.00014 m=M_PASS
M14 (VOUT net13 VIN VIN) g45p2svt w=(W_PASS*NF_PASS) l=L_PASS nf=NF_PASS as=(1.0142857142857143e-07*((W_PASS*NF_PASS))) ad=(1.0142857142857143e-07*((W_PASS*NF_PASS))) ps=max(2*((W_PASS*NF_PASS))+(-0.00033289999999999996),0) pd=max(2*((W_PASS*NF_PASS))+(-0.00033289999999999996),0) nrd=(1.0142859999999999e-07/((W_PASS*NF_PASS))) nrs=(1.0142859999999999e-07/((W_PASS*NF_PASS))) sa=150n sb=150n sd=200n sca=10.31048 scb=0.00999 scc=0.00014 m=M_PASS
M12 (VOUT net13 VIN VIN) g45p2svt w=(W_PASS*NF_PASS) l=L_PASS nf=NF_PASS as=(1.0142857142857143e-07*((W_PASS*NF_PASS))) ad=(1.0142857142857143e-07*((W_PASS*NF_PASS))) ps=max(2*((W_PASS*NF_PASS))+(-0.00033289999999999996),0) pd=max(2*((W_PASS*NF_PASS))+(-0.00033289999999999996),0) nrd=(1.0142859999999999e-07/((W_PASS*NF_PASS))) nrs=(1.0142859999999999e-07/((W_PASS*NF_PASS))) sa=150n sb=150n sd=200n sca=10.31048 scb=0.00999 scc=0.00014 m=M_PASS
M13 (VOUT net13 VIN VIN) g45p2svt w=(W_PASS*NF_PASS) l=L_PASS nf=NF_PASS as=(1.0142857142857143e-07*((W_PASS*NF_PASS))) ad=(1.0142857142857143e-07*((W_PASS*NF_PASS))) ps=max(2*((W_PASS*NF_PASS))+(-0.00033289999999999996),0) pd=max(2*((W_PASS*NF_PASS))+(-0.00033289999999999996),0) nrd=(1.0142859999999999e-07/((W_PASS*NF_PASS))) nrs=(1.0142859999999999e-07/((W_PASS*NF_PASS))) sa=150n sb=150n sd=200n sca=10.31048 scb=0.00999 scc=0.00014 m=M_PASS
M11 (VOUT net13 VIN VIN) g45p2svt w=(W_PASS*NF_PASS) l=L_PASS nf=NF_PASS as=(1.0142857142857143e-07*((W_PASS*NF_PASS))) ad=(1.0142857142857143e-07*((W_PASS*NF_PASS))) ps=max(2*((W_PASS*NF_PASS))+(-0.00033289999999999996),0) pd=max(2*((W_PASS*NF_PASS))+(-0.00033289999999999996),0) nrd=(1.0142859999999999e-07/((W_PASS*NF_PASS))) nrs=(1.0142859999999999e-07/((W_PASS*NF_PASS))) sa=150n sb=150n sd=200n sca=10.31048 scb=0.00999 scc=0.00014 m=M_PASS
M9 (net12 net11 net10 VIN) g45p2svt w=(W_BUF*NF_BUF) l=L_BUF nf=NF_BUF as=(1.5000000000000002e-07*((W_BUF*NF_BUF))) ad=(1.5000000000000002e-07*((W_BUF*NF_BUF))) ps=max(2*((W_BUF*NF_BUF))+(2.9999999999999967e-07),0) pd=max(2*((W_BUF*NF_BUF))+(2.9999999999999967e-07),0) nrd=(1.5000000000000002e-07/((W_BUF*NF_BUF))) nrs=(1.5000000000000002e-07/((W_BUF*NF_BUF))) sa=150n sb=150n sd=200n sca=12.06869 scb=0.01143 scc=0.00019 m=M_BUF
C2 (net4 net11) capacitor c=C_C
C0 (net13 net12) capacitor c=C_G
C1 (VOUT net6) capacitor c=C_FF
M5 (net1 net2 VDD_core VDD_core) g45p1svt w=(W_LD*NF_LD) l=L_LD nf=NF_LD as=(1.4e-07*((W_LD*NF_LD))) ad=(1.4e-07*((W_LD*NF_LD))) ps=max(2*((W_LD*NF_LD))+(2.79999999999999e-07),0) pd=max(2*((W_LD*NF_LD))+(2.79999999999999e-07),0) nrd=(1.399998e-07/((W_LD*NF_LD))) nrs=(1.399998e-07/((W_LD*NF_LD))) sa=140n sb=140n sd=160n sca=31.81634 scb=0.03611 scc=0.00298 m=M_LD
M6 (net2 net2 VDD_core VDD_core) g45p1svt w=(W_LD*NF_LD) l=L_LD nf=NF_LD as=(1.4e-07*((W_LD*NF_LD))) ad=(1.4e-07*((W_LD*NF_LD))) ps=max(2*((W_LD*NF_LD))+(2.79999999999999e-07),0) pd=max(2*((W_LD*NF_LD))+(2.79999999999999e-07),0) nrd=(1.399998e-07/((W_LD*NF_LD))) nrs=(1.399998e-07/((W_LD*NF_LD))) sa=140n sb=140n sd=160n sca=31.81634 scb=0.03611 scc=0.00298 m=M_LD
M7 (net11 net1 VDD_core VDD_core) g45p1svt w=(W_CS2*NF_CS2) l=L_CS2 nf=NF_CS2 as=(8.240000000000001e-08*((W_CS2*NF_CS2))) ad=(8.240000000000001e-08*((W_CS2*NF_CS2))) ps=max(2*((W_CS2*NF_CS2))+(-0.00023588),0) pd=max(2*((W_CS2*NF_CS2))+(-0.00023588),0) nrd=(8.24e-08/((W_CS2*NF_CS2))) nrs=(8.24e-08/((W_CS2*NF_CS2))) sa=140n sb=140n sd=160n sca=29.62924 scb=0.03494 scc=0.00276 m=M_CS2
M0 (net3 net3 gnd gnd) g45n1svt w=(W_MIR*NF_MIR) l=L_MIR nf=NF_MIR as=(1.4e-07*((W_MIR*NF_MIR))) ad=(1.4e-07*((W_MIR*NF_MIR))) ps=max(2*((W_MIR*NF_MIR))+(2.79999999999999e-07),0) pd=max(2*((W_MIR*NF_MIR))+(2.79999999999999e-07),0) nrd=(1.4e-07/((W_MIR*NF_MIR))) nrs=(1.4e-07/((W_MIR*NF_MIR))) sa=140n sb=140n sd=160n sca=34.52597 scb=0.03757 scc=0.00325 m=M_MIR
M1 (net5 net3 gnd gnd) g45n1svt w=(W_MIR*NF_MIR) l=L_MIR nf=NF_MIR as=(1.4e-07*((W_MIR*NF_MIR))) ad=(1.4e-07*((W_MIR*NF_MIR))) ps=max(2*((W_MIR*NF_MIR))+(2.79999999999999e-07),0) pd=max(2*((W_MIR*NF_MIR))+(2.79999999999999e-07),0) nrd=(1.4e-07/((W_MIR*NF_MIR))) nrs=(1.4e-07/((W_MIR*NF_MIR))) sa=140n sb=140n sd=160n sca=34.52597 scb=0.03757 scc=0.00325 m=M_MIR
M2 (net1 VREF net5 gnd) g45n1svt w=(W_IN*NF_IN) l=L_IN nf=NF_IN as=(1.4e-07*((W_IN*NF_IN))) ad=(1.4e-07*((W_IN*NF_IN))) ps=max(2*((W_IN*NF_IN))+(2.79999999999999e-07),0) pd=max(2*((W_IN*NF_IN))+(2.79999999999999e-07),0) nrd=(1.4e-07/((W_IN*NF_IN))) nrs=(1.4e-07/((W_IN*NF_IN))) sa=140n sb=140n sd=160n sca=34.52597 scb=0.03757 scc=0.00325 m=M_IN
M3 (net11 net3 gnd gnd) g45n1svt w=(W_SNK*NF_SNK) l=L_MIR nf=NF_SNK as=(9.2e-08*((W_SNK*NF_SNK))) ad=(9.2e-08*((W_SNK*NF_SNK))) ps=max(2*((W_SNK*NF_SNK))+(-3.907999999999999e-05),0) pd=max(2*((W_SNK*NF_SNK))+(-3.907999999999999e-05),0) nrd=(9.199999999999999e-08/((W_SNK*NF_SNK))) nrs=(9.199999999999999e-08/((W_SNK*NF_SNK))) sa=140n sb=140n sd=160n sca=29.62924 scb=0.03494 scc=0.00276 m=M_SNK
IPRB_LOOP (net6 net6__lp) iprobe
M4 (net2 net6__lp net5 gnd) g45n1svt w=(W_IN*NF_IN) l=L_IN nf=NF_IN as=(1.4e-07*((W_IN*NF_IN))) ad=(1.4e-07*((W_IN*NF_IN))) ps=max(2*((W_IN*NF_IN))+(2.79999999999999e-07),0) pd=max(2*((W_IN*NF_IN))+(2.79999999999999e-07),0) nrd=(1.4e-07/((W_IN*NF_IN))) nrs=(1.4e-07/((W_IN*NF_IN))) sa=140n sb=140n sd=160n sca=34.52597 scb=0.03757 scc=0.00325 m=M_IN
R10 (VIN net10) resistor r=R_S
R9 (net13 net12) resistor r=R_G
R8 (net6 gnd) resistor r=R_FB_BOT
R7 (net12 gnd) resistor r=R_B
R11 (VOUT net6) resistor r=R_FB_TOP
R0 (net4 net1) resistor r=R_Z
ends ldo_erroramp_dac_dut
