// Design: DAC_20261109_FWR/DC_AC_tb
simulator lang=spectre
global 0
include "<PDK_ROOT>/gpdk180/models/spectre/gpdk.scs" section=NN

// DAC_20261109_FWR/fgpmos/schematic
subckt fgpmos B D GBIAS GSIGNAL S
    MP (D FG S B) pmos1 w=7.8883e-05 l=2.96e-07 m=1
    C2 (GSIGNAL FG) capacitor c=1.17e-12
    C1 (GBIAS FG) capacitor c=1.442e-12
    R2 (GSIGNAL FG) resistor r=1T
    R1 (GBIAS FG) resistor r=1T
ends fgpmos

// DAC_20261109_FWR/fwr_fig4/schematic
subckt fwr_fig4 GND OUT VBIAS VDD X Y
    M14 (OUT SQ GND GND) nmos1 w=3.6656e-05 l=3.46e-07 m=1
    M11 (PMBIAS SQ GND GND) nmos1 w=4.2713e-05 l=6.37e-07 m=1
    M10 (SQ SQ GND GND) nmos1 w=2.1464e-05 l=3.03e-07 m=1
    M9 (SQ SQ GND GND) nmos1 w=1.0732e-05 l=3.03e-07 m=1
    M6 (Z C Y GND) nmos1 w=2.518e-06 l=3.205e-06 m=1
    M5 (Y Y GND GND) nmos1 w=1.1858e-05 l=2.485e-06 m=1
    M4 (Z C X GND) nmos1 w=2.518e-06 l=3.205e-06 m=1
    M3 (X X GND GND) nmos1 w=1.1858e-05 l=2.485e-06 m=1
    M2 (BIAS BIAS GND GND) nmos1 w=2.0996e-05 l=2.22e-07 m=1
    M1 (C C BIAS GND) nmos1 w=1.4709e-05 l=4.29e-07 m=1
    M8 (VDD SQ VBIAS Z VDD) fgpmos
    M7 (VDD Z VBIAS Z VDD) fgpmos
    M13 (C PMBIAS VDD VDD) pmos1 w=5.899e-06 l=7.51e-07 m=1
    M12 (PMBIAS PMBIAS VDD VDD) pmos1 w=1.6953e-05 l=2.74e-07 m=1
ends fwr_fig4

// DAC_20261109_FWR/DC_AC_tb/schematic
DUT (0 OUT VBIAS VDD X Y) fwr_fig4
OUT_SRC (OUT 0) vsource dc=.7 type=dc
VBIAS_SRC (VBIAS 0) vsource dc=.2 type=dc
VDD_SRC (VDD 0) vsource dc=.7 type=dc
IIN (Y X) isource dc=17.5u mag=1 type=dc
simulatorOptions options reltol=1e-6 vabstol=1e-9 iabstol=1e-15 temp=100 gmin=1e-15 maxwarns=20
saveOptions options save=selected currents=selected
save OUT_SRC:p VDD_SRC:p VBIAS_SRC:p
dcOp dc
dc dc dev=IIN param=dc start=-35u stop=35u step=.25u
ac ac start=10 stop=1G dec=100
