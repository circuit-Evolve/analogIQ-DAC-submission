// Generated by analogiq from dut_benchmark.scs (sha256 a80b6b75d775d638).
// Connectivity and device models are unchanged except for the listed transformations:
//   - fgpmos.MP: junction geometry as/ad/ps/pd rewritten in terms of the bound width (area = Lj*W, perimeter = 2*W + c; Lj and c from the netlist)
//   - M14: junction geometry as/ad/ps/pd rewritten in terms of the bound width (area = Lj*W, perimeter = 2*W + c; Lj and c from the netlist)
//   - M11: junction geometry as/ad/ps/pd rewritten in terms of the bound width (area = Lj*W, perimeter = 2*W + c; Lj and c from the netlist)
//   - M10: junction geometry as/ad/ps/pd rewritten in terms of the bound width (area = Lj*W, perimeter = 2*W + c; Lj and c from the netlist)
//   - M9: junction geometry as/ad/ps/pd rewritten in terms of the bound width (area = Lj*W, perimeter = 2*W + c; Lj and c from the netlist)
//   - M6: junction geometry as/ad/ps/pd rewritten in terms of the bound width (area = Lj*W, perimeter = 2*W + c; Lj and c from the netlist)
//   - M5: junction geometry as/ad/ps/pd rewritten in terms of the bound width (area = Lj*W, perimeter = 2*W + c; Lj and c from the netlist)
//   - M4: junction geometry as/ad/ps/pd rewritten in terms of the bound width (area = Lj*W, perimeter = 2*W + c; Lj and c from the netlist)
//   - M3: junction geometry as/ad/ps/pd rewritten in terms of the bound width (area = Lj*W, perimeter = 2*W + c; Lj and c from the netlist)
//   - M2: junction geometry as/ad/ps/pd rewritten in terms of the bound width (area = Lj*W, perimeter = 2*W + c; Lj and c from the netlist)
//   - M1: junction geometry as/ad/ps/pd rewritten in terms of the bound width (area = Lj*W, perimeter = 2*W + c; Lj and c from the netlist)
//   - M13: junction geometry as/ad/ps/pd rewritten in terms of the bound width (area = Lj*W, perimeter = 2*W + c; Lj and c from the netlist)
//   - M12: junction geometry as/ad/ps/pd rewritten in terms of the bound width (area = Lj*W, perimeter = 2*W + c; Lj and c from the netlist)
//   - sizing variables bound inside local subckts are subckt parameters passed from the DUT instance(s): fgpmos: ['C_BIAS', 'C_SIG', 'L_FG', 'M_FG', 'W_FG']
//   - widths bound to sizing variables on fold-capable devices are folded symbolically into ceil(W/max) fingers of W/ceil(W/max) (per-device max [1e-05] m): M1, M10, M11, M12, M13, M14, M2, M3, M4, M5, M6, M9, fgpmos.MP
subckt fgpmos (B D GBIAS GSIGNAL S)
  parameters C_BIAS=1e-12 C_SIG=1e-12 L_FG=1e-06 M_FG=1.0 W_FG=1e-06
  MP (D FG S B) pmos1 w=(W_FG/max(1, W_FG/1e-05)) l=L_FG as=(6.000000000000001e-07*((W_FG/max(1, W_FG/1e-05)))) ad=(6.000000000000001e-07*((W_FG/max(1, W_FG/1e-05)))) ps=max(2*((W_FG/max(1, W_FG/1e-05)))+(1.200000000000002e-06),0) pd=max(2*((W_FG/max(1, W_FG/1e-05)))+(1.200000000000002e-06),0) m=M_FG*max(1, W_FG/1e-05)
  C2 (GSIGNAL FG) capacitor c=C_SIG
  C1 (GBIAS FG) capacitor c=C_BIAS
  R2 (GSIGNAL FG) resistor r=1T
  R1 (GBIAS FG) resistor r=1T
ends fgpmos
subckt fgmos_rectifier_dut (GND OUT VBIAS VDD X Y)
parameters W_IN=1e-06 L_IN=1e-06 W_CAS=1e-06 L_CAS=1e-06 W_B1=1e-06 L_B1=1e-06 W_B2=1e-06 L_B2=1e-06 W_SQ=1e-06 L_SQ=1e-06 W_FB=1e-06 L_FB=1e-06 W_PM=1e-06 L_PM=1e-06 W_PMO=1e-06 L_PMO=1e-06 W_OUT=1e-06 L_OUT=1e-06 W_FG=1e-06 L_FG=1e-06 C_BIAS=1e-12 C_SIG=1e-12 M_IN=1.0 M_CAS=1.0 M_B1=1.0 M_B2=1.0 M_SQ=1.0 M_FB=1.0 M_PM=1.0 M_PMO=1.0 M_OUT=1.0 M_FG=1.0
M14 (OUT SQ GND GND) nmos1 w=(W_OUT/max(1, W_OUT/1e-05)) l=L_OUT as=(6e-07*((W_OUT/max(1, W_OUT/1e-05)))) ad=(6e-07*((W_OUT/max(1, W_OUT/1e-05)))) ps=max(2*((W_OUT/max(1, W_OUT/1e-05)))+(1.1999999999999885e-06),0) pd=max(2*((W_OUT/max(1, W_OUT/1e-05)))+(1.1999999999999885e-06),0) m=M_OUT*max(1, W_OUT/1e-05)
M11 (PMBIAS SQ GND GND) nmos1 w=(W_FB/max(1, W_FB/1e-05)) l=L_FB as=(6e-07*((W_FB/max(1, W_FB/1e-05)))) ad=(6e-07*((W_FB/max(1, W_FB/1e-05)))) ps=max(2*((W_FB/max(1, W_FB/1e-05)))+(1.1999999999999885e-06),0) pd=max(2*((W_FB/max(1, W_FB/1e-05)))+(1.1999999999999885e-06),0) m=M_FB*max(1, W_FB/1e-05)
M10 (SQ SQ GND GND) nmos1 w=((2*W_SQ)/max(1, (2*W_SQ)/1e-05)) l=L_SQ as=(6.000000000000001e-07*(((2*W_SQ)/max(1, (2*W_SQ)/1e-05)))) ad=(6.000000000000001e-07*(((2*W_SQ)/max(1, (2*W_SQ)/1e-05)))) ps=max(2*(((2*W_SQ)/max(1, (2*W_SQ)/1e-05)))+(1.200000000000002e-06),0) pd=max(2*(((2*W_SQ)/max(1, (2*W_SQ)/1e-05)))+(1.200000000000002e-06),0) m=M_SQ*max(1, (2*W_SQ)/1e-05)
M9 (SQ SQ GND GND) nmos1 w=(W_SQ/max(1, W_SQ/1e-05)) l=L_SQ as=(6.000000000000001e-07*((W_SQ/max(1, W_SQ/1e-05)))) ad=(6.000000000000001e-07*((W_SQ/max(1, W_SQ/1e-05)))) ps=max(2*((W_SQ/max(1, W_SQ/1e-05)))+(1.1999999999999987e-06),0) pd=max(2*((W_SQ/max(1, W_SQ/1e-05)))+(1.1999999999999987e-06),0) m=M_SQ*max(1, W_SQ/1e-05)
M6 (Z C Y GND) nmos1 w=(W_CAS/max(1, W_CAS/1e-05)) l=L_CAS as=(6.000000000000001e-07*((W_CAS/max(1, W_CAS/1e-05)))) ad=(6.000000000000001e-07*((W_CAS/max(1, W_CAS/1e-05)))) ps=max(2*((W_CAS/max(1, W_CAS/1e-05)))+(1.2000000000000004e-06),0) pd=max(2*((W_CAS/max(1, W_CAS/1e-05)))+(1.2000000000000004e-06),0) m=M_CAS*max(1, W_CAS/1e-05)
M5 (Y Y GND GND) nmos1 w=(W_IN/max(1, W_IN/1e-05)) l=L_IN as=(6e-07*((W_IN/max(1, W_IN/1e-05)))) ad=(6e-07*((W_IN/max(1, W_IN/1e-05)))) ps=max(2*((W_IN/max(1, W_IN/1e-05)))+(1.1999999999999987e-06),0) pd=max(2*((W_IN/max(1, W_IN/1e-05)))+(1.1999999999999987e-06),0) m=M_IN*max(1, W_IN/1e-05)
M4 (Z C X GND) nmos1 w=(W_CAS/max(1, W_CAS/1e-05)) l=L_CAS as=(6.000000000000001e-07*((W_CAS/max(1, W_CAS/1e-05)))) ad=(6.000000000000001e-07*((W_CAS/max(1, W_CAS/1e-05)))) ps=max(2*((W_CAS/max(1, W_CAS/1e-05)))+(1.2000000000000004e-06),0) pd=max(2*((W_CAS/max(1, W_CAS/1e-05)))+(1.2000000000000004e-06),0) m=M_CAS*max(1, W_CAS/1e-05)
M3 (X X GND GND) nmos1 w=(W_IN/max(1, W_IN/1e-05)) l=L_IN as=(6e-07*((W_IN/max(1, W_IN/1e-05)))) ad=(6e-07*((W_IN/max(1, W_IN/1e-05)))) ps=max(2*((W_IN/max(1, W_IN/1e-05)))+(1.1999999999999987e-06),0) pd=max(2*((W_IN/max(1, W_IN/1e-05)))+(1.1999999999999987e-06),0) m=M_IN*max(1, W_IN/1e-05)
M2 (BIAS BIAS GND GND) nmos1 w=(W_B2/max(1, W_B2/1e-05)) l=L_B2 as=(6e-07*((W_B2/max(1, W_B2/1e-05)))) ad=(6e-07*((W_B2/max(1, W_B2/1e-05)))) ps=max(2*((W_B2/max(1, W_B2/1e-05)))+(1.200000000000002e-06),0) pd=max(2*((W_B2/max(1, W_B2/1e-05)))+(1.200000000000002e-06),0) m=M_B2*max(1, W_B2/1e-05)
M1 (C C BIAS GND) nmos1 w=(W_B1/max(1, W_B1/1e-05)) l=L_B1 as=(6.000000000000001e-07*((W_B1/max(1, W_B1/1e-05)))) ad=(6.000000000000001e-07*((W_B1/max(1, W_B1/1e-05)))) ps=max(2*((W_B1/max(1, W_B1/1e-05)))+(1.1999999999999987e-06),0) pd=max(2*((W_B1/max(1, W_B1/1e-05)))+(1.1999999999999987e-06),0) m=M_B1*max(1, W_B1/1e-05)
M8 (VDD SQ VBIAS Z VDD) fgpmos C_BIAS=C_BIAS C_SIG=C_SIG L_FG=L_FG M_FG=M_FG W_FG=W_FG
M7 (VDD Z VBIAS Z VDD) fgpmos C_BIAS=C_BIAS C_SIG=C_SIG L_FG=L_FG M_FG=M_FG W_FG=W_FG
M13 (C PMBIAS VDD VDD) pmos1 w=(W_PMO/max(1, W_PMO/1e-05)) l=L_PMO as=(6.000000000000001e-07*((W_PMO/max(1, W_PMO/1e-05)))) ad=(6.000000000000001e-07*((W_PMO/max(1, W_PMO/1e-05)))) ps=max(2*((W_PMO/max(1, W_PMO/1e-05)))+(1.2000000000000004e-06),0) pd=max(2*((W_PMO/max(1, W_PMO/1e-05)))+(1.2000000000000004e-06),0) m=M_PMO*max(1, W_PMO/1e-05)
M12 (PMBIAS PMBIAS VDD VDD) pmos1 w=(W_PM/max(1, W_PM/1e-05)) l=L_PM as=(6.000000000000001e-07*((W_PM/max(1, W_PM/1e-05)))) ad=(6.000000000000001e-07*((W_PM/max(1, W_PM/1e-05)))) ps=max(2*((W_PM/max(1, W_PM/1e-05)))+(1.200000000000002e-06),0) pd=max(2*((W_PM/max(1, W_PM/1e-05)))+(1.200000000000002e-06),0) m=M_PM*max(1, W_PM/1e-05)
ends fgmos_rectifier_dut
