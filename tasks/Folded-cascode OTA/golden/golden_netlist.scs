// Golden sizing netlist (curator 2026-10-28): the benchmark DUT subckt with its parameter defaults set to
// the golden design (golden_design.json), taken from the verified run's job NN_T0_S0p89/amp_fd_dc_v1.
// The DUT subckt and its parameter values are the same in every job of that run (only the testbench changes).
// Instance line of that run: XDUT (vdd vss inp inn out outn vocm) fcrobust01_dut C_COMP=1.3552971065120634e-13 I_BIAS=4.144154674863611e-06 L_B15=2.3276926076416978e-07 L_B5=5.204783177990777e-07 L_B6=1.2058896038340272e-06 L_B9=...
// Testbench-level variables (bias sources, operating levels) are in golden_design.json and testbench decks.
// Generated by analogiq from dut_benchmark.scs (sha256 39ef5d4d0996f607).
// Connectivity and device models are unchanged except for the listed transformations:
//   - ideal elements kept inside the DUT: I_BIAS
//   - PMOS_4: junction geometry as/ad/ps/pd rewritten in terms of the bound width (area = Lj*W, perimeter = 2*W + c; Lj and c from the netlist)
//   - PMOS_3: junction geometry as/ad/ps/pd rewritten in terms of the bound width (area = Lj*W, perimeter = 2*W + c; Lj and c from the netlist)
//   - PMOS_27: junction geometry as/ad/ps/pd rewritten in terms of the bound width (area = Lj*W, perimeter = 2*W + c; Lj and c from the netlist)
//   - PMOS_26: junction geometry as/ad/ps/pd rewritten in terms of the bound width (area = Lj*W, perimeter = 2*W + c; Lj and c from the netlist)
//   - PMOS_25: junction geometry as/ad/ps/pd rewritten in terms of the bound width (area = Lj*W, perimeter = 2*W + c; Lj and c from the netlist)
//   - PMOS_24: junction geometry as/ad/ps/pd rewritten in terms of the bound width (area = Lj*W, perimeter = 2*W + c; Lj and c from the netlist)
//   - PMOS_21: junction geometry as/ad/ps/pd rewritten in terms of the bound width (area = Lj*W, perimeter = 2*W + c; Lj and c from the netlist)
//   - PMOS_2: junction geometry as/ad/ps/pd rewritten in terms of the bound width (area = Lj*W, perimeter = 2*W + c; Lj and c from the netlist)
//   - PMOS_18: junction geometry as/ad/ps/pd rewritten in terms of the bound width (area = Lj*W, perimeter = 2*W + c; Lj and c from the netlist)
//   - PMOS_17: junction geometry as/ad/ps/pd rewritten in terms of the bound width (area = Lj*W, perimeter = 2*W + c; Lj and c from the netlist)
//   - PMOS_14: junction geometry as/ad/ps/pd rewritten in terms of the bound width (area = Lj*W, perimeter = 2*W + c; Lj and c from the netlist)
//   - PMOS_13: junction geometry as/ad/ps/pd rewritten in terms of the bound width (area = Lj*W, perimeter = 2*W + c; Lj and c from the netlist)
//   - NMOS_CROSS_1: junction geometry as/ad/ps/pd rewritten in terms of the bound width (area = Lj*W, perimeter = 2*W + c; Lj and c from the netlist)
//   - NMOS_CROSS_0: junction geometry as/ad/ps/pd rewritten in terms of the bound width (area = Lj*W, perimeter = 2*W + c; Lj and c from the netlist)
//   - NMOS_9: junction geometry as/ad/ps/pd rewritten in terms of the bound width (area = Lj*W, perimeter = 2*W + c; Lj and c from the netlist)
//   - NMOS_8: junction geometry as/ad/ps/pd rewritten in terms of the bound width (area = Lj*W, perimeter = 2*W + c; Lj and c from the netlist)
//   - NMOS_7: junction geometry as/ad/ps/pd rewritten in terms of the bound width (area = Lj*W, perimeter = 2*W + c; Lj and c from the netlist)
//   - NMOS_6: junction geometry as/ad/ps/pd rewritten in terms of the bound width (area = Lj*W, perimeter = 2*W + c; Lj and c from the netlist)
//   - NMOS_5: junction geometry as/ad/ps/pd rewritten in terms of the bound width (area = Lj*W, perimeter = 2*W + c; Lj and c from the netlist)
//   - NMOS_29: junction geometry as/ad/ps/pd rewritten in terms of the bound width (area = Lj*W, perimeter = 2*W + c; Lj and c from the netlist)
//   - NMOS_28: junction geometry as/ad/ps/pd rewritten in terms of the bound width (area = Lj*W, perimeter = 2*W + c; Lj and c from the netlist)
//   - NMOS_22: junction geometry as/ad/ps/pd rewritten in terms of the bound width (area = Lj*W, perimeter = 2*W + c; Lj and c from the netlist)
//   - NMOS_20: junction geometry as/ad/ps/pd rewritten in terms of the bound width (area = Lj*W, perimeter = 2*W + c; Lj and c from the netlist)
//   - NMOS_19: junction geometry as/ad/ps/pd rewritten in terms of the bound width (area = Lj*W, perimeter = 2*W + c; Lj and c from the netlist)
//   - NMOS_16: junction geometry as/ad/ps/pd rewritten in terms of the bound width (area = Lj*W, perimeter = 2*W + c; Lj and c from the netlist)
//   - NMOS_15: junction geometry as/ad/ps/pd rewritten in terms of the bound width (area = Lj*W, perimeter = 2*W + c; Lj and c from the netlist)
//   - NMOS_12: junction geometry as/ad/ps/pd rewritten in terms of the bound width (area = Lj*W, perimeter = 2*W + c; Lj and c from the netlist)
//   - NMOS_11: junction geometry as/ad/ps/pd rewritten in terms of the bound width (area = Lj*W, perimeter = 2*W + c; Lj and c from the netlist)
//   - NMOS_10: junction geometry as/ad/ps/pd rewritten in terms of the bound width (area = Lj*W, perimeter = 2*W + c; Lj and c from the netlist)
//   - widths bound to sizing variables on fold-capable devices are folded symbolically into ceil(W/max) fingers of W/ceil(W/max) (per-device max [1e-05] m): NMOS_10, NMOS_11, NMOS_12, NMOS_15, NMOS_16, NMOS_19, NMOS_20, NMOS_22, NMOS_28, NMOS_29, NMOS_5, NMOS_6, NMOS_7, NMOS_8, NMOS_9, NMOS_CROSS_0, NMOS_CROSS_1, PMOS_13, PMOS_14, PMOS_17, PMOS_18, PMOS_2, PMOS_21, PMOS_24, PMOS_25, PMOS_26, PMOS_27, PMOS_3, PMOS_4
subckt fcrobust01_dut (VDD VSS VIN_L VIN_R OUT_L OUT_R VCM_REF)
parameters W_IN=1.4363869637043722e-05 L_IN=1.2781305644576157e-06 W_TAIL=8.712758413886145e-06 L_TAIL=4.726446053846039e-06 W_TOP=1.0249167746717064e-06 L_TOP=2.627011904939889e-07 W_PCAS=6.5923941329221776e-06 L_PCAS=2.1365049978610163e-07 W_NCAS=1.468911880011994e-06 L_NCAS=9.99721524582168e-07 W_NBOT=1.5656356852240995e-05 L_NBOT=2.9278479893759537e-07 W_CS=6.197393272281429e-06 L_CS=6.413414351539381e-07 W_SINK=3.517797633178804e-05 L_SINK=1.6127153936292393e-06 W_CMTAIL=9.03251294652229e-06 L_CMTAIL=4.65916436816158e-06 W_CMIN=8.707641159611446e-06 L_CMIN=6.181579379898664e-07 W_CMDIO=1.7320047270450245e-06 L_CMDIO=4.466184713146856e-06 W_B6=7.5292099224681086e-06 L_B6=1.2058896038340272e-06 W_B15=4.647681193388753e-05 L_B15=2.3276926076416978e-07 W_BX0=2.535209067927858e-06 L_BX0=8.828755788976787e-07 W_BX1=3.1441790536203074e-05 L_BX1=1.9651639535008034e-06 W_B5=1.0508962007075856e-06 L_B5=5.204783177990777e-07 W_B9=1.395887534364419e-05 L_B9=4.1852046342456203e-07 W_P25=1.087075943680119e-06 L_P25=6.577877956317699e-07 W_P13=5.60695945437082e-06 L_P13=1.808844914253336e-05 W_P2=5.524382705082382e-06 L_P2=2.6580936790747357e-07 C_COMP=1.3552971065120634e-13 R_SENSE=28541.084332490485 I_BIAS=4.144154674863611e-06
C_L (LOW_L OUT_L) capacitor c=C_COMP
C_R (OUT_R LOW_R) capacitor c=C_COMP
I_BIAS (VDD BN_UPPER) isource type=dc dc=I_BIAS
PMOS_4 (CAS_R BP_CASCADE FOLD_R VDD) pmos1 w=(W_PCAS/max(1, W_PCAS/1e-05)) l=L_PCAS m=max(1, W_PCAS/1e-05) as=(6.000000000000001e-07*((W_PCAS/max(1, W_PCAS/1e-05)))) ad=(6.000000000000001e-07*((W_PCAS/max(1, W_PCAS/1e-05)))) ps=max(2*((W_PCAS/max(1, W_PCAS/1e-05)))+(1.2e-06),0) pd=max(2*((W_PCAS/max(1, W_PCAS/1e-05)))+(1.2e-06),0)
PMOS_3 (OUT_R CAS_R VDD VDD) pmos1 w=(W_CS/max(1, W_CS/1e-05)) l=L_CS m=max(1, W_CS/1e-05) as=(6.000000000000001e-07*((W_CS/max(1, W_CS/1e-05)))) ad=(6.000000000000001e-07*((W_CS/max(1, W_CS/1e-05)))) ps=max(2*((W_CS/max(1, W_CS/1e-05)))+(1.2e-06),0) pd=max(2*((W_CS/max(1, W_CS/1e-05)))+(1.2e-06),0)
PMOS_27 (FOLD_L BP_SINGLE VDD VDD) pmos1 w=(W_TOP/max(1, W_TOP/1e-05)) l=L_TOP m=max(1, W_TOP/1e-05) as=(6.000000000000001e-07*((W_TOP/max(1, W_TOP/1e-05)))) ad=(6.000000000000001e-07*((W_TOP/max(1, W_TOP/1e-05)))) ps=max(2*((W_TOP/max(1, W_TOP/1e-05)))+(1.2e-06),0) pd=max(2*((W_TOP/max(1, W_TOP/1e-05)))+(1.2e-06),0)
PMOS_26 (CM_TAIL BP_SINGLE VDD VDD) pmos1 w=(W_CMTAIL/max(1, W_CMTAIL/1e-05)) l=L_CMTAIL m=max(1, W_CMTAIL/1e-05) as=(6.000000000000001e-07*((W_CMTAIL/max(1, W_CMTAIL/1e-05)))) ad=(6.000000000000001e-07*((W_CMTAIL/max(1, W_CMTAIL/1e-05)))) ps=max(2*((W_CMTAIL/max(1, W_CMTAIL/1e-05)))+(1.2e-06),0) pd=max(2*((W_CMTAIL/max(1, W_CMTAIL/1e-05)))+(1.2e-06),0)
PMOS_25 (BP_SINGLE BP_SINGLE VDD VDD) pmos1 w=(W_P25/max(1, W_P25/1e-05)) l=L_P25 m=max(1, W_P25/1e-05) as=(6.000000000000001e-07*((W_P25/max(1, W_P25/1e-05)))) ad=(6.000000000000001e-07*((W_P25/max(1, W_P25/1e-05)))) ps=max(2*((W_P25/max(1, W_P25/1e-05)))+(1.2e-06),0) pd=max(2*((W_P25/max(1, W_P25/1e-05)))+(1.2e-06),0)
PMOS_24 (CM_L VCM_REF CM_TAIL VDD) pmos1 w=(W_CMIN/max(1, W_CMIN/1e-05)) l=L_CMIN m=max(1, W_CMIN/1e-05) as=(6.000000000000001e-07*((W_CMIN/max(1, W_CMIN/1e-05)))) ad=(6.000000000000001e-07*((W_CMIN/max(1, W_CMIN/1e-05)))) ps=max(2*((W_CMIN/max(1, W_CMIN/1e-05)))+(1.2e-06),0) pd=max(2*((W_CMIN/max(1, W_CMIN/1e-05)))+(1.2e-06),0)
PMOS_21 (CM_R VCM_SENSE CM_TAIL VDD) pmos1 w=(W_CMIN/max(1, W_CMIN/1e-05)) l=L_CMIN m=max(1, W_CMIN/1e-05) as=(6.000000000000001e-07*((W_CMIN/max(1, W_CMIN/1e-05)))) ad=(6.000000000000001e-07*((W_CMIN/max(1, W_CMIN/1e-05)))) ps=max(2*((W_CMIN/max(1, W_CMIN/1e-05)))+(1.2e-06),0) pd=max(2*((W_CMIN/max(1, W_CMIN/1e-05)))+(1.2e-06),0)
PMOS_2 (BP_CASCADE BP_CASCADE BP_STACK VDD) pmos1 w=(W_P2/max(1, W_P2/1e-05)) l=L_P2 m=max(1, W_P2/1e-05) as=(6.000000000000001e-07*((W_P2/max(1, W_P2/1e-05)))) ad=(6.000000000000001e-07*((W_P2/max(1, W_P2/1e-05)))) ps=max(2*((W_P2/max(1, W_P2/1e-05)))+(1.2e-06),0) pd=max(2*((W_P2/max(1, W_P2/1e-05)))+(1.2e-06),0)
PMOS_18 (FOLD_R BP_SINGLE VDD VDD) pmos1 w=(W_TOP/max(1, W_TOP/1e-05)) l=L_TOP m=max(1, W_TOP/1e-05) as=(6.000000000000001e-07*((W_TOP/max(1, W_TOP/1e-05)))) ad=(6.000000000000001e-07*((W_TOP/max(1, W_TOP/1e-05)))) ps=max(2*((W_TOP/max(1, W_TOP/1e-05)))+(1.2e-06),0) pd=max(2*((W_TOP/max(1, W_TOP/1e-05)))+(1.2e-06),0)
PMOS_17 (CAS_L BP_CASCADE FOLD_L VDD) pmos1 w=(W_PCAS/max(1, W_PCAS/1e-05)) l=L_PCAS m=max(1, W_PCAS/1e-05) as=(6.000000000000001e-07*((W_PCAS/max(1, W_PCAS/1e-05)))) ad=(6.000000000000001e-07*((W_PCAS/max(1, W_PCAS/1e-05)))) ps=max(2*((W_PCAS/max(1, W_PCAS/1e-05)))+(1.2e-06),0) pd=max(2*((W_PCAS/max(1, W_PCAS/1e-05)))+(1.2e-06),0)
PMOS_14 (OUT_L CAS_L VDD VDD) pmos1 w=(W_CS/max(1, W_CS/1e-05)) l=L_CS m=max(1, W_CS/1e-05) as=(6.000000000000001e-07*((W_CS/max(1, W_CS/1e-05)))) ad=(6.000000000000001e-07*((W_CS/max(1, W_CS/1e-05)))) ps=max(2*((W_CS/max(1, W_CS/1e-05)))+(1.2e-06),0) pd=max(2*((W_CS/max(1, W_CS/1e-05)))+(1.2e-06),0)
PMOS_13 (BP_STACK BP_CASCADE VDD VDD) pmos1 w=(W_P13/max(1, W_P13/1e-05)) l=L_P13 m=max(1, W_P13/1e-05) as=(6.000000000000001e-07*((W_P13/max(1, W_P13/1e-05)))) ad=(6.000000000000001e-07*((W_P13/max(1, W_P13/1e-05)))) ps=max(2*((W_P13/max(1, W_P13/1e-05)))+(1.2e-06),0) pd=max(2*((W_P13/max(1, W_P13/1e-05)))+(1.2e-06),0)
R_R (VCM_SENSE OUT_R) resistor r=R_SENSE
R_L (VCM_SENSE OUT_L) resistor r=R_SENSE
NMOS_CROSS_1 (BP_SINGLE BN_UPPER BN_STACK1 VSS) nmos1 w=(W_BX1/max(1, W_BX1/1e-05)) l=L_BX1 m=max(1, W_BX1/1e-05) as=(6.000000000000001e-07*((W_BX1/max(1, W_BX1/1e-05)))) ad=(6.000000000000001e-07*((W_BX1/max(1, W_BX1/1e-05)))) ps=max(2*((W_BX1/max(1, W_BX1/1e-05)))+(1.2e-06),0) pd=max(2*((W_BX1/max(1, W_BX1/1e-05)))+(1.2e-06),0)
NMOS_CROSS_0 (BN_STACK1 BN_LOWER VSS VSS) nmos1 w=(W_BX0/max(1, W_BX0/1e-05)) l=L_BX0 m=max(1, W_BX0/1e-05) as=(6.000000000000001e-07*((W_BX0/max(1, W_BX0/1e-05)))) ad=(6.000000000000001e-07*((W_BX0/max(1, W_BX0/1e-05)))) ps=max(2*((W_BX0/max(1, W_BX0/1e-05)))+(1.2e-06),0) pd=max(2*((W_BX0/max(1, W_BX0/1e-05)))+(1.2e-06),0)
NMOS_9 (BP_CASCADE BN_UPPER BN_STACK2 VSS) nmos1 w=(W_B9/max(1, W_B9/1e-05)) l=L_B9 m=max(1, W_B9/1e-05) as=(6.000000000000001e-07*((W_B9/max(1, W_B9/1e-05)))) ad=(6.000000000000001e-07*((W_B9/max(1, W_B9/1e-05)))) ps=max(2*((W_B9/max(1, W_B9/1e-05)))+(1.2e-06),0) pd=max(2*((W_B9/max(1, W_B9/1e-05)))+(1.2e-06),0)
NMOS_8 (CM_L CM_L VSS VSS) nmos1 w=(W_CMDIO/max(1, W_CMDIO/1e-05)) l=L_CMDIO m=max(1, W_CMDIO/1e-05) as=(6.000000000000001e-07*((W_CMDIO/max(1, W_CMDIO/1e-05)))) ad=(6.000000000000001e-07*((W_CMDIO/max(1, W_CMDIO/1e-05)))) ps=max(2*((W_CMDIO/max(1, W_CMDIO/1e-05)))+(1.2e-06),0) pd=max(2*((W_CMDIO/max(1, W_CMDIO/1e-05)))+(1.2e-06),0)
NMOS_7 (LOW_R CM_R VSS VSS) nmos1 w=(W_NBOT/max(1, W_NBOT/1e-05)) l=L_NBOT m=max(1, W_NBOT/1e-05) as=(6.000000000000001e-07*((W_NBOT/max(1, W_NBOT/1e-05)))) ad=(6.000000000000001e-07*((W_NBOT/max(1, W_NBOT/1e-05)))) ps=max(2*((W_NBOT/max(1, W_NBOT/1e-05)))+(1.2e-06),0) pd=max(2*((W_NBOT/max(1, W_NBOT/1e-05)))+(1.2e-06),0)
NMOS_6 (BN_LOWER BN_LOWER VSS VSS) nmos1 w=(W_B6/max(1, W_B6/1e-05)) l=L_B6 m=max(1, W_B6/1e-05) as=(6.000000000000001e-07*((W_B6/max(1, W_B6/1e-05)))) ad=(6.000000000000001e-07*((W_B6/max(1, W_B6/1e-05)))) ps=max(2*((W_B6/max(1, W_B6/1e-05)))+(1.2e-06),0) pd=max(2*((W_B6/max(1, W_B6/1e-05)))+(1.2e-06),0)
NMOS_5 (BN_STACK2 BN_LOWER VSS VSS) nmos1 w=(W_B5/max(1, W_B5/1e-05)) l=L_B5 m=max(1, W_B5/1e-05) as=(6.000000000000001e-07*((W_B5/max(1, W_B5/1e-05)))) ad=(6.000000000000001e-07*((W_B5/max(1, W_B5/1e-05)))) ps=max(2*((W_B5/max(1, W_B5/1e-05)))+(1.2e-06),0) pd=max(2*((W_B5/max(1, W_B5/1e-05)))+(1.2e-06),0)
NMOS_29 (TAIL BN_LOWER VSS VSS) nmos1 w=(W_TAIL/max(1, W_TAIL/1e-05)) l=L_TAIL m=max(1, W_TAIL/1e-05) as=(6.000000000000001e-07*((W_TAIL/max(1, W_TAIL/1e-05)))) ad=(6.000000000000001e-07*((W_TAIL/max(1, W_TAIL/1e-05)))) ps=max(2*((W_TAIL/max(1, W_TAIL/1e-05)))+(1.2e-06),0) pd=max(2*((W_TAIL/max(1, W_TAIL/1e-05)))+(1.2e-06),0)
NMOS_28 (OUT_R BN_LOWER VSS VSS) nmos1 w=(W_SINK/max(1, W_SINK/1e-05)) l=L_SINK m=max(1, W_SINK/1e-05) as=(6.000000000000001e-07*((W_SINK/max(1, W_SINK/1e-05)))) ad=(6.000000000000001e-07*((W_SINK/max(1, W_SINK/1e-05)))) ps=max(2*((W_SINK/max(1, W_SINK/1e-05)))+(1.2e-06),0) pd=max(2*((W_SINK/max(1, W_SINK/1e-05)))+(1.2e-06),0)
NMOS_22 (FOLD_L VIN_L TAIL VSS) nmos1 w=(W_IN/max(1, W_IN/1e-05)) l=L_IN m=max(1, W_IN/1e-05) as=(6.000000000000001e-07*((W_IN/max(1, W_IN/1e-05)))) ad=(6.000000000000001e-07*((W_IN/max(1, W_IN/1e-05)))) ps=max(2*((W_IN/max(1, W_IN/1e-05)))+(1.2e-06),0) pd=max(2*((W_IN/max(1, W_IN/1e-05)))+(1.2e-06),0)
NMOS_20 (OUT_L BN_LOWER VSS VSS) nmos1 w=(W_SINK/max(1, W_SINK/1e-05)) l=L_SINK m=max(1, W_SINK/1e-05) as=(6.000000000000001e-07*((W_SINK/max(1, W_SINK/1e-05)))) ad=(6.000000000000001e-07*((W_SINK/max(1, W_SINK/1e-05)))) ps=max(2*((W_SINK/max(1, W_SINK/1e-05)))+(1.2e-06),0) pd=max(2*((W_SINK/max(1, W_SINK/1e-05)))+(1.2e-06),0)
NMOS_19 (FOLD_R VIN_R TAIL VSS) nmos1 w=(W_IN/max(1, W_IN/1e-05)) l=L_IN m=max(1, W_IN/1e-05) as=(6.000000000000001e-07*((W_IN/max(1, W_IN/1e-05)))) ad=(6.000000000000001e-07*((W_IN/max(1, W_IN/1e-05)))) ps=max(2*((W_IN/max(1, W_IN/1e-05)))+(1.2e-06),0) pd=max(2*((W_IN/max(1, W_IN/1e-05)))+(1.2e-06),0)
NMOS_16 (CAS_L BN_UPPER LOW_L VSS) nmos1 w=(W_NCAS/max(1, W_NCAS/1e-05)) l=L_NCAS m=max(1, W_NCAS/1e-05) as=(6.000000000000001e-07*((W_NCAS/max(1, W_NCAS/1e-05)))) ad=(6.000000000000001e-07*((W_NCAS/max(1, W_NCAS/1e-05)))) ps=max(2*((W_NCAS/max(1, W_NCAS/1e-05)))+(1.2e-06),0) pd=max(2*((W_NCAS/max(1, W_NCAS/1e-05)))+(1.2e-06),0)
NMOS_15 (BN_UPPER BN_UPPER BN_LOWER VSS) nmos1 w=(W_B15/max(1, W_B15/1e-05)) l=L_B15 m=max(1, W_B15/1e-05) as=(6.000000000000001e-07*((W_B15/max(1, W_B15/1e-05)))) ad=(6.000000000000001e-07*((W_B15/max(1, W_B15/1e-05)))) ps=max(2*((W_B15/max(1, W_B15/1e-05)))+(1.2e-06),0) pd=max(2*((W_B15/max(1, W_B15/1e-05)))+(1.2e-06),0)
NMOS_12 (CAS_R BN_UPPER LOW_R VSS) nmos1 w=(W_NCAS/max(1, W_NCAS/1e-05)) l=L_NCAS m=max(1, W_NCAS/1e-05) as=(6.000000000000001e-07*((W_NCAS/max(1, W_NCAS/1e-05)))) ad=(6.000000000000001e-07*((W_NCAS/max(1, W_NCAS/1e-05)))) ps=max(2*((W_NCAS/max(1, W_NCAS/1e-05)))+(1.2e-06),0) pd=max(2*((W_NCAS/max(1, W_NCAS/1e-05)))+(1.2e-06),0)
NMOS_11 (LOW_L CM_R VSS VSS) nmos1 w=(W_NBOT/max(1, W_NBOT/1e-05)) l=L_NBOT m=max(1, W_NBOT/1e-05) as=(6.000000000000001e-07*((W_NBOT/max(1, W_NBOT/1e-05)))) ad=(6.000000000000001e-07*((W_NBOT/max(1, W_NBOT/1e-05)))) ps=max(2*((W_NBOT/max(1, W_NBOT/1e-05)))+(1.2e-06),0) pd=max(2*((W_NBOT/max(1, W_NBOT/1e-05)))+(1.2e-06),0)
NMOS_10 (CM_R CM_R VSS VSS) nmos1 w=(W_CMDIO/max(1, W_CMDIO/1e-05)) l=L_CMDIO m=max(1, W_CMDIO/1e-05) as=(6.000000000000001e-07*((W_CMDIO/max(1, W_CMDIO/1e-05)))) ad=(6.000000000000001e-07*((W_CMDIO/max(1, W_CMDIO/1e-05)))) ps=max(2*((W_CMDIO/max(1, W_CMDIO/1e-05)))+(1.2e-06),0) pd=max(2*((W_CMDIO/max(1, W_CMDIO/1e-05)))+(1.2e-06),0)
ends fcrobust01_dut
