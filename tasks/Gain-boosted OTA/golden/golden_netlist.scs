// Golden sizing netlist (curator 2026-10-28): the benchmark DUT subckt with its parameter defaults set to
// the golden design (golden_design.json), taken from the verified run's job NN_T27_S1p00/amp_fd_dc_v1.
// The DUT subckt and its parameter values are the same in every job of that run (only the testbench changes).
// Instance line of that run: XDUT (vdd vss inn inp out outn vocm b_Vb1 b_N_VB1 b_N_VB2 b_N_VB3 b_N_VB4 b_P_VB1 b_P_VB2 b_P_VB3 b_P_VB4) gbfc21_dut L_N1=1.833671576266807e-07 L_N10=1.1261634269250477e-06 L_N3=2.3024167195286244e-0...
// Testbench-level variables (bias sources, operating levels) are in golden_design.json and testbench decks.
// Generated by analogiq from final.scs (sha256 2871a1aa20842bc0).
// Connectivity and device models are unchanged except for the listed transformations:
//   - M_Mp1: junction geometry ad/as/pd/ps rewritten in terms of the bound width (area = Lj*W, perimeter = 2*W + c; Lj and c from the netlist)
//   - M_Mp2: junction geometry ad/as/pd/ps rewritten in terms of the bound width (area = Lj*W, perimeter = 2*W + c; Lj and c from the netlist)
//   - M_Mp3: junction geometry ad/as/pd/ps rewritten in terms of the bound width (area = Lj*W, perimeter = 2*W + c; Lj and c from the netlist)
//   - M_Mp4: junction geometry ad/as/pd/ps rewritten in terms of the bound width (area = Lj*W, perimeter = 2*W + c; Lj and c from the netlist)
//   - M_Mp5: junction geometry ad/as/pd/ps rewritten in terms of the bound width (area = Lj*W, perimeter = 2*W + c; Lj and c from the netlist)
//   - M_Mp6: junction geometry ad/as/pd/ps rewritten in terms of the bound width (area = Lj*W, perimeter = 2*W + c; Lj and c from the netlist)
//   - M_Mp7: junction geometry ad/as/pd/ps rewritten in terms of the bound width (area = Lj*W, perimeter = 2*W + c; Lj and c from the netlist)
//   - M_Mp8: junction geometry ad/as/pd/ps rewritten in terms of the bound width (area = Lj*W, perimeter = 2*W + c; Lj and c from the netlist)
//   - M_Mp9: junction geometry ad/as/pd/ps rewritten in terms of the bound width (area = Lj*W, perimeter = 2*W + c; Lj and c from the netlist)
//   - M_Mp10: junction geometry ad/as/pd/ps rewritten in terms of the bound width (area = Lj*W, perimeter = 2*W + c; Lj and c from the netlist)
//   - M_Mp11: junction geometry ad/as/pd/ps rewritten in terms of the bound width (area = Lj*W, perimeter = 2*W + c; Lj and c from the netlist)
//   - M_Mp12: junction geometry ad/as/pd/ps rewritten in terms of the bound width (area = Lj*W, perimeter = 2*W + c; Lj and c from the netlist)
//   - M_Mp13: junction geometry ad/as/pd/ps rewritten in terms of the bound width (area = Lj*W, perimeter = 2*W + c; Lj and c from the netlist)
//   - M_Mn1: junction geometry ad/as/pd/ps rewritten in terms of the bound width (area = Lj*W, perimeter = 2*W + c; Lj and c from the netlist)
//   - M_Mn2: junction geometry ad/as/pd/ps rewritten in terms of the bound width (area = Lj*W, perimeter = 2*W + c; Lj and c from the netlist)
//   - M_Mn3: junction geometry ad/as/pd/ps rewritten in terms of the bound width (area = Lj*W, perimeter = 2*W + c; Lj and c from the netlist)
//   - M_Mn4: junction geometry ad/as/pd/ps rewritten in terms of the bound width (area = Lj*W, perimeter = 2*W + c; Lj and c from the netlist)
//   - M_Mn9: junction geometry ad/as/pd/ps rewritten in terms of the bound width (area = Lj*W, perimeter = 2*W + c; Lj and c from the netlist)
//   - M_Mn10: junction geometry ad/as/pd/ps rewritten in terms of the bound width (area = Lj*W, perimeter = 2*W + c; Lj and c from the netlist)
//   - N_Mp1: junction geometry ad/as/pd/ps rewritten in terms of the bound width (area = Lj*W, perimeter = 2*W + c; Lj and c from the netlist)
//   - N_Mp2: junction geometry ad/as/pd/ps rewritten in terms of the bound width (area = Lj*W, perimeter = 2*W + c; Lj and c from the netlist)
//   - N_Mp3: junction geometry ad/as/pd/ps rewritten in terms of the bound width (area = Lj*W, perimeter = 2*W + c; Lj and c from the netlist)
//   - N_Mp4: junction geometry ad/as/pd/ps rewritten in terms of the bound width (area = Lj*W, perimeter = 2*W + c; Lj and c from the netlist)
//   - N_Mn1: junction geometry ad/as/pd/ps rewritten in terms of the bound width (area = Lj*W, perimeter = 2*W + c; Lj and c from the netlist)
//   - N_Mn2: junction geometry ad/as/pd/ps rewritten in terms of the bound width (area = Lj*W, perimeter = 2*W + c; Lj and c from the netlist)
//   - N_Mn3: junction geometry ad/as/pd/ps rewritten in terms of the bound width (area = Lj*W, perimeter = 2*W + c; Lj and c from the netlist)
//   - N_Mn4: junction geometry ad/as/pd/ps rewritten in terms of the bound width (area = Lj*W, perimeter = 2*W + c; Lj and c from the netlist)
//   - N_Mn5: junction geometry ad/as/pd/ps rewritten in terms of the bound width (area = Lj*W, perimeter = 2*W + c; Lj and c from the netlist)
//   - N_Mn6: junction geometry ad/as/pd/ps rewritten in terms of the bound width (area = Lj*W, perimeter = 2*W + c; Lj and c from the netlist)
//   - N_Mn7: junction geometry ad/as/pd/ps rewritten in terms of the bound width (area = Lj*W, perimeter = 2*W + c; Lj and c from the netlist)
//   - N_Mn8: junction geometry ad/as/pd/ps rewritten in terms of the bound width (area = Lj*W, perimeter = 2*W + c; Lj and c from the netlist)
//   - N_Mn9: junction geometry ad/as/pd/ps rewritten in terms of the bound width (area = Lj*W, perimeter = 2*W + c; Lj and c from the netlist)
//   - P_Mp1: junction geometry ad/as/pd/ps rewritten in terms of the bound width (area = Lj*W, perimeter = 2*W + c; Lj and c from the netlist)
//   - P_Mp2: junction geometry ad/as/pd/ps rewritten in terms of the bound width (area = Lj*W, perimeter = 2*W + c; Lj and c from the netlist)
//   - P_Mp3: junction geometry ad/as/pd/ps rewritten in terms of the bound width (area = Lj*W, perimeter = 2*W + c; Lj and c from the netlist)
//   - P_Mp4: junction geometry ad/as/pd/ps rewritten in terms of the bound width (area = Lj*W, perimeter = 2*W + c; Lj and c from the netlist)
//   - P_Mp5: junction geometry ad/as/pd/ps rewritten in terms of the bound width (area = Lj*W, perimeter = 2*W + c; Lj and c from the netlist)
//   - P_Mp6: junction geometry ad/as/pd/ps rewritten in terms of the bound width (area = Lj*W, perimeter = 2*W + c; Lj and c from the netlist)
//   - P_Mp7: junction geometry ad/as/pd/ps rewritten in terms of the bound width (area = Lj*W, perimeter = 2*W + c; Lj and c from the netlist)
//   - P_Mp8: junction geometry ad/as/pd/ps rewritten in terms of the bound width (area = Lj*W, perimeter = 2*W + c; Lj and c from the netlist)
//   - P_Mp9: junction geometry ad/as/pd/ps rewritten in terms of the bound width (area = Lj*W, perimeter = 2*W + c; Lj and c from the netlist)
//   - P_Mn1: junction geometry ad/as/pd/ps rewritten in terms of the bound width (area = Lj*W, perimeter = 2*W + c; Lj and c from the netlist)
//   - P_Mn2: junction geometry ad/as/pd/ps rewritten in terms of the bound width (area = Lj*W, perimeter = 2*W + c; Lj and c from the netlist)
//   - P_Mn3: junction geometry ad/as/pd/ps rewritten in terms of the bound width (area = Lj*W, perimeter = 2*W + c; Lj and c from the netlist)
//   - P_Mn4: junction geometry ad/as/pd/ps rewritten in terms of the bound width (area = Lj*W, perimeter = 2*W + c; Lj and c from the netlist)
//   - widths bound to sizing variables on fold-capable devices are folded symbolically into ceil(W/max) fingers of W/ceil(W/max) (per-device max [1e-05] m): M_Mn1, M_Mn10, M_Mn2, M_Mn3, M_Mn4, M_Mn9, M_Mp1, M_Mp10, M_Mp11, M_Mp12, M_Mp13, M_Mp2, M_Mp3, M_Mp4, M_Mp5, M_Mp6, M_Mp7, M_Mp8, M_Mp9, N_Mn1, N_Mn2, N_Mn3, N_Mn4, N_Mn5, N_Mn6, N_Mn7, N_Mn8, N_Mn9, N_Mp1, N_Mp2, N_Mp3, N_Mp4, P_Mn1, P_Mn2, P_Mn3, P_Mn4, P_Mp1, P_Mp2, P_Mp3, P_Mp4, P_Mp5, P_Mp6, P_Mp7, P_Mp8, P_Mp9
subckt gbfc21_dut (VDD VSS VINM VINP VOUTM VOUTP VCM Vb1 N_VB1 N_VB2 N_VB3 N_VB4 P_VB1 P_VB2 P_VB3 P_VB4)
parameters W_P1=4.4693471404332474e-05 L_P1=7.491337573184951e-07 M_P1=4.0 W_P3=1.9945905676852887e-05 L_P3=7.190303663850801e-07 W_P5=4.235494258179319e-06 L_P5=9.402550972815747e-07 W_P7=3.1716790541058182e-06 L_P7=1.0071535034980243e-06 W_P8=3.4953154851122517e-06 L_P8=7.961068171362562e-07 W_P11=2.6963274866122663e-05 L_P11=1.8042848782219106e-07 M_P11=7.0 W_P13=5.0354033340228764e-05 L_P13=2.683289566236754e-07 M_P13=5.0 W_N1=1.7062649186963613e-05 L_N1=1.833671576266807e-07 W_N3=4.8040870914085316e-05 L_N3=2.3024167195286244e-07 M_N3=2.0 W_N9=6.723831456800867e-07 L_N9=1.2329778919446686e-06 W_N10=6.638347305959683e-07 L_N10=1.1261634269250477e-06 W_NA1=8.850519176426786e-06 L_NA1=1.196261612484985e-06 W_NA3=2.7629685411850235e-06 L_NA3=2.3965777609117113e-07 W_NA_C=1.6568058512711616e-06 L_NA_C=1.6674313559396812e-06 W_NA_S=9.148793647305493e-07 L_NA_S=1.2784377851590638e-06 W_NA5=1.3278495109903709e-05 L_NA5=1.1265811533411335e-06 W_NA7=1.961120001091517e-06 L_NA7=2.393542757725299e-07 W_NA9=6.817267432829173e-06 L_NA9=9.588063424213262e-07 W_PA1=2.2928860571630774e-06 L_PA1=1.5232825585925327e-06 W_PA3=2.350074687607823e-06 L_PA3=1.2490152299025404e-06 W_PA5=3.1748823451840748e-06 L_PA5=2.00785890338564e-07 W_PA7=2.7660622902621976e-05 L_PA7=1.0420907964771762e-06 M_PA7=3.0 W_PA9=1.6046988218807006e-05 L_PA9=9.84035080858604e-07 W_PA_C=6.166900005899355e-07 L_PA_C=2.2933452167914513e-07 W_PA_S=3.3672382503423904e-06 L_PA_S=1.0653172985212379e-06
M_Mp1 (A1 Vb1 VDD VDD) pmos1 w=(W_P1/max(1, W_P1/1e-05)) l=L_P1 m=M_P1*max(1, W_P1/1e-05) ad=(6.000000000000001e-07*((W_P1/max(1, W_P1/1e-05)))) as=(6.000000000000001e-07*((W_P1/max(1, W_P1/1e-05)))) pd=max(2*((W_P1/max(1, W_P1/1e-05)))+(1.200000000000002e-06),0) ps=max(2*((W_P1/max(1, W_P1/1e-05)))+(1.200000000000002e-06),0)
M_Mp2 (A1p Vb1 VDD VDD) pmos1 w=(W_P1/max(1, W_P1/1e-05)) l=L_P1 m=M_P1*max(1, W_P1/1e-05) ad=(6.000000000000001e-07*((W_P1/max(1, W_P1/1e-05)))) as=(6.000000000000001e-07*((W_P1/max(1, W_P1/1e-05)))) pd=max(2*((W_P1/max(1, W_P1/1e-05)))+(1.200000000000002e-06),0) ps=max(2*((W_P1/max(1, W_P1/1e-05)))+(1.200000000000002e-06),0)
M_Mp3 (VOUTP NOUTM A1 VDD) pmos1 w=(W_P3/max(1, W_P3/1e-05)) l=L_P3 m=max(1, W_P3/1e-05) ad=(6.000000000000001e-07*((W_P3/max(1, W_P3/1e-05)))) as=(6.000000000000001e-07*((W_P3/max(1, W_P3/1e-05)))) pd=max(2*((W_P3/max(1, W_P3/1e-05)))+(1.200000000000002e-06),0) ps=max(2*((W_P3/max(1, W_P3/1e-05)))+(1.200000000000002e-06),0)
M_Mp4 (VOUTM NOUTP A1p VDD) pmos1 w=(W_P3/max(1, W_P3/1e-05)) l=L_P3 m=max(1, W_P3/1e-05) ad=(6.000000000000001e-07*((W_P3/max(1, W_P3/1e-05)))) as=(6.000000000000001e-07*((W_P3/max(1, W_P3/1e-05)))) pd=max(2*((W_P3/max(1, W_P3/1e-05)))+(1.200000000000002e-06),0) ps=max(2*((W_P3/max(1, W_P3/1e-05)))+(1.200000000000002e-06),0)
M_Mp5 (CM_L Vb1 VDD VDD) pmos1 w=(W_P5/max(1, W_P5/1e-05)) l=L_P5 m=max(1, W_P5/1e-05) ad=(6e-07*((W_P5/max(1, W_P5/1e-05)))) as=(6e-07*((W_P5/max(1, W_P5/1e-05)))) pd=max(2*((W_P5/max(1, W_P5/1e-05)))+(1.2000000000000004e-06),0) ps=max(2*((W_P5/max(1, W_P5/1e-05)))+(1.2000000000000004e-06),0)
M_Mp6 (CM_R Vb1 VDD VDD) pmos1 w=(W_P5/max(1, W_P5/1e-05)) l=L_P5 m=max(1, W_P5/1e-05) ad=(6e-07*((W_P5/max(1, W_P5/1e-05)))) as=(6e-07*((W_P5/max(1, W_P5/1e-05)))) pd=max(2*((W_P5/max(1, W_P5/1e-05)))+(1.2000000000000004e-06),0) ps=max(2*((W_P5/max(1, W_P5/1e-05)))+(1.2000000000000004e-06),0)
M_Mp7 (CM_OUTER VOUTM CM_L VDD) pmos1 w=(W_P7/max(1, W_P7/1e-05)) l=L_P7 m=max(1, W_P7/1e-05) ad=(6e-07*((W_P7/max(1, W_P7/1e-05)))) as=(6e-07*((W_P7/max(1, W_P7/1e-05)))) pd=max(2*((W_P7/max(1, W_P7/1e-05)))+(1.2000000000000004e-06),0) ps=max(2*((W_P7/max(1, W_P7/1e-05)))+(1.2000000000000004e-06),0)
M_Mp8 (CMFB VCM CM_L VDD) pmos1 w=(W_P8/max(1, W_P8/1e-05)) l=L_P8 m=max(1, W_P8/1e-05) ad=(6e-07*((W_P8/max(1, W_P8/1e-05)))) as=(6e-07*((W_P8/max(1, W_P8/1e-05)))) pd=max(2*((W_P8/max(1, W_P8/1e-05)))+(1.2000000000000004e-06),0) ps=max(2*((W_P8/max(1, W_P8/1e-05)))+(1.2000000000000004e-06),0)
M_Mp9 (CMFB VCM CM_R VDD) pmos1 w=(W_P8/max(1, W_P8/1e-05)) l=L_P8 m=max(1, W_P8/1e-05) ad=(6e-07*((W_P8/max(1, W_P8/1e-05)))) as=(6e-07*((W_P8/max(1, W_P8/1e-05)))) pd=max(2*((W_P8/max(1, W_P8/1e-05)))+(1.2000000000000004e-06),0) ps=max(2*((W_P8/max(1, W_P8/1e-05)))+(1.2000000000000004e-06),0)
M_Mp10 (CM_OUTER VOUTP CM_R VDD) pmos1 w=(W_P7/max(1, W_P7/1e-05)) l=L_P7 m=max(1, W_P7/1e-05) ad=(6e-07*((W_P7/max(1, W_P7/1e-05)))) as=(6e-07*((W_P7/max(1, W_P7/1e-05)))) pd=max(2*((W_P7/max(1, W_P7/1e-05)))+(1.2000000000000004e-06),0) ps=max(2*((W_P7/max(1, W_P7/1e-05)))+(1.2000000000000004e-06),0)
M_Mp11 (B1p VINM TAIL_P VDD) pmos1 w=(W_P11/max(1, W_P11/1e-05)) l=L_P11 m=M_P11*max(1, W_P11/1e-05) ad=(6.000000000000001e-07*((W_P11/max(1, W_P11/1e-05)))) as=(6.000000000000001e-07*((W_P11/max(1, W_P11/1e-05)))) pd=max(2*((W_P11/max(1, W_P11/1e-05)))+(1.200000000000002e-06),0) ps=max(2*((W_P11/max(1, W_P11/1e-05)))+(1.200000000000002e-06),0)
M_Mp12 (B1 VINP TAIL_P VDD) pmos1 w=(W_P11/max(1, W_P11/1e-05)) l=L_P11 m=M_P11*max(1, W_P11/1e-05) ad=(6.000000000000001e-07*((W_P11/max(1, W_P11/1e-05)))) as=(6.000000000000001e-07*((W_P11/max(1, W_P11/1e-05)))) pd=max(2*((W_P11/max(1, W_P11/1e-05)))+(1.200000000000002e-06),0) ps=max(2*((W_P11/max(1, W_P11/1e-05)))+(1.200000000000002e-06),0)
M_Mp13 (TAIL_P Vb1 VDD VDD) pmos1 w=(W_P13/max(1, W_P13/1e-05)) l=L_P13 m=M_P13*max(1, W_P13/1e-05) ad=(6.000000000000001e-07*((W_P13/max(1, W_P13/1e-05)))) as=(6.000000000000001e-07*((W_P13/max(1, W_P13/1e-05)))) pd=max(2*((W_P13/max(1, W_P13/1e-05)))+(1.200000000000002e-06),0) ps=max(2*((W_P13/max(1, W_P13/1e-05)))+(1.200000000000002e-06),0)
M_Mn1 (VOUTP POUTM B1 VSS) nmos1 w=(W_N1/max(1, W_N1/1e-05)) l=L_N1 m=max(1, W_N1/1e-05) ad=(6.000000000000001e-07*((W_N1/max(1, W_N1/1e-05)))) as=(6.000000000000001e-07*((W_N1/max(1, W_N1/1e-05)))) pd=max(2*((W_N1/max(1, W_N1/1e-05)))+(1.1999999999999987e-06),0) ps=max(2*((W_N1/max(1, W_N1/1e-05)))+(1.1999999999999987e-06),0)
M_Mn2 (VOUTM POUTP B1p VSS) nmos1 w=(W_N1/max(1, W_N1/1e-05)) l=L_N1 m=max(1, W_N1/1e-05) ad=(6.000000000000001e-07*((W_N1/max(1, W_N1/1e-05)))) as=(6.000000000000001e-07*((W_N1/max(1, W_N1/1e-05)))) pd=max(2*((W_N1/max(1, W_N1/1e-05)))+(1.1999999999999987e-06),0) ps=max(2*((W_N1/max(1, W_N1/1e-05)))+(1.1999999999999987e-06),0)
M_Mn3 (B1 CMFB VSS VSS) nmos1 w=(W_N3/max(1, W_N3/1e-05)) l=L_N3 m=M_N3*max(1, W_N3/1e-05) ad=(6.000000000000001e-07*((W_N3/max(1, W_N3/1e-05)))) as=(6.000000000000001e-07*((W_N3/max(1, W_N3/1e-05)))) pd=max(2*((W_N3/max(1, W_N3/1e-05)))+(1.200000000000002e-06),0) ps=max(2*((W_N3/max(1, W_N3/1e-05)))+(1.200000000000002e-06),0)
M_Mn4 (B1p CMFB VSS VSS) nmos1 w=(W_N3/max(1, W_N3/1e-05)) l=L_N3 m=M_N3*max(1, W_N3/1e-05) ad=(6.000000000000001e-07*((W_N3/max(1, W_N3/1e-05)))) as=(6.000000000000001e-07*((W_N3/max(1, W_N3/1e-05)))) pd=max(2*((W_N3/max(1, W_N3/1e-05)))+(1.200000000000002e-06),0) ps=max(2*((W_N3/max(1, W_N3/1e-05)))+(1.200000000000002e-06),0)
M_Mn9 (CMFB CMFB VSS VSS) nmos1 w=(W_N9/max(1, W_N9/1e-05)) l=L_N9 m=max(1, W_N9/1e-05) ad=(6e-07*((W_N9/max(1, W_N9/1e-05)))) as=(6e-07*((W_N9/max(1, W_N9/1e-05)))) pd=max(2*((W_N9/max(1, W_N9/1e-05)))+(1.2e-06),0) ps=max(2*((W_N9/max(1, W_N9/1e-05)))+(1.2e-06),0)
M_Mn10 (CM_OUTER CM_OUTER VSS VSS) nmos1 w=(W_N10/max(1, W_N10/1e-05)) l=L_N10 m=max(1, W_N10/1e-05) ad=(6e-07*((W_N10/max(1, W_N10/1e-05)))) as=(6e-07*((W_N10/max(1, W_N10/1e-05)))) pd=max(2*((W_N10/max(1, W_N10/1e-05)))+(1.2e-06),0) ps=max(2*((W_N10/max(1, W_N10/1e-05)))+(1.2e-06),0)
N_Mp1 (N_FOLD_L N_VB1 VDD VDD) pmos1 w=(W_NA1/max(1, W_NA1/1e-05)) l=L_NA1 m=max(1, W_NA1/1e-05) ad=(6.000000000000001e-07*((W_NA1/max(1, W_NA1/1e-05)))) as=(6.000000000000001e-07*((W_NA1/max(1, W_NA1/1e-05)))) pd=max(2*((W_NA1/max(1, W_NA1/1e-05)))+(1.1999999999999987e-06),0) ps=max(2*((W_NA1/max(1, W_NA1/1e-05)))+(1.1999999999999987e-06),0)
N_Mp2 (N_FOLD_R N_VB1 VDD VDD) pmos1 w=(W_NA1/max(1, W_NA1/1e-05)) l=L_NA1 m=max(1, W_NA1/1e-05) ad=(6.000000000000001e-07*((W_NA1/max(1, W_NA1/1e-05)))) as=(6.000000000000001e-07*((W_NA1/max(1, W_NA1/1e-05)))) pd=max(2*((W_NA1/max(1, W_NA1/1e-05)))+(1.1999999999999987e-06),0) ps=max(2*((W_NA1/max(1, W_NA1/1e-05)))+(1.1999999999999987e-06),0)
N_Mp3 (NOUTP N_VB2 N_FOLD_L VDD) pmos1 w=(W_NA3/max(1, W_NA3/1e-05)) l=L_NA3 m=max(1, W_NA3/1e-05) ad=(6.000000000000001e-07*((W_NA3/max(1, W_NA3/1e-05)))) as=(6.000000000000001e-07*((W_NA3/max(1, W_NA3/1e-05)))) pd=max(2*((W_NA3/max(1, W_NA3/1e-05)))+(1.2e-06),0) ps=max(2*((W_NA3/max(1, W_NA3/1e-05)))+(1.2e-06),0)
N_Mp4 (NOUTM N_VB2 N_FOLD_R VDD) pmos1 w=(W_NA3/max(1, W_NA3/1e-05)) l=L_NA3 m=max(1, W_NA3/1e-05) ad=(6.000000000000001e-07*((W_NA3/max(1, W_NA3/1e-05)))) as=(6.000000000000001e-07*((W_NA3/max(1, W_NA3/1e-05)))) pd=max(2*((W_NA3/max(1, W_NA3/1e-05)))+(1.2e-06),0) ps=max(2*((W_NA3/max(1, W_NA3/1e-05)))+(1.2e-06),0)
N_Mn1 (NOUTP N_VB3 N_NSTACK_L VSS) nmos1 w=(W_NA_C/max(1, W_NA_C/1e-05)) l=L_NA_C m=max(1, W_NA_C/1e-05) ad=(6e-07*((W_NA_C/max(1, W_NA_C/1e-05)))) as=(6e-07*((W_NA_C/max(1, W_NA_C/1e-05)))) pd=max(2*((W_NA_C/max(1, W_NA_C/1e-05)))+(1.2e-06),0) ps=max(2*((W_NA_C/max(1, W_NA_C/1e-05)))+(1.2e-06),0)
N_Mn2 (NOUTM N_VB3 N_NSTACK_R VSS) nmos1 w=(W_NA_C/max(1, W_NA_C/1e-05)) l=L_NA_C m=max(1, W_NA_C/1e-05) ad=(6e-07*((W_NA_C/max(1, W_NA_C/1e-05)))) as=(6e-07*((W_NA_C/max(1, W_NA_C/1e-05)))) pd=max(2*((W_NA_C/max(1, W_NA_C/1e-05)))+(1.2e-06),0) ps=max(2*((W_NA_C/max(1, W_NA_C/1e-05)))+(1.2e-06),0)
N_Mn3 (N_NSTACK_L N_VB4 VSS VSS) nmos1 w=(W_NA_S/max(1, W_NA_S/1e-05)) l=L_NA_S m=max(1, W_NA_S/1e-05) ad=(6e-07*((W_NA_S/max(1, W_NA_S/1e-05)))) as=(6e-07*((W_NA_S/max(1, W_NA_S/1e-05)))) pd=max(2*((W_NA_S/max(1, W_NA_S/1e-05)))+(1.2e-06),0) ps=max(2*((W_NA_S/max(1, W_NA_S/1e-05)))+(1.2e-06),0)
N_Mn4 (N_NSTACK_R N_VB4 VSS VSS) nmos1 w=(W_NA_S/max(1, W_NA_S/1e-05)) l=L_NA_S m=max(1, W_NA_S/1e-05) ad=(6e-07*((W_NA_S/max(1, W_NA_S/1e-05)))) as=(6e-07*((W_NA_S/max(1, W_NA_S/1e-05)))) pd=max(2*((W_NA_S/max(1, W_NA_S/1e-05)))+(1.2e-06),0) ps=max(2*((W_NA_S/max(1, W_NA_S/1e-05)))+(1.2e-06),0)
N_Mn5 (N_CMFB_SUM NOUTM VSS VSS) nmos1 w=(W_NA5/max(1, W_NA5/1e-05)) l=L_NA5 m=max(1, W_NA5/1e-05) ad=(6.000000000000001e-07*((W_NA5/max(1, W_NA5/1e-05)))) as=(6.000000000000001e-07*((W_NA5/max(1, W_NA5/1e-05)))) pd=max(2*((W_NA5/max(1, W_NA5/1e-05)))+(1.200000000000002e-06),0) ps=max(2*((W_NA5/max(1, W_NA5/1e-05)))+(1.200000000000002e-06),0)
N_Mn6 (N_CMFB_SUM NOUTP VSS VSS) nmos1 w=(W_NA5/max(1, W_NA5/1e-05)) l=L_NA5 m=max(1, W_NA5/1e-05) ad=(6.000000000000001e-07*((W_NA5/max(1, W_NA5/1e-05)))) as=(6.000000000000001e-07*((W_NA5/max(1, W_NA5/1e-05)))) pd=max(2*((W_NA5/max(1, W_NA5/1e-05)))+(1.200000000000002e-06),0) ps=max(2*((W_NA5/max(1, W_NA5/1e-05)))+(1.200000000000002e-06),0)
N_Mn7 (N_FOLD_R A1 N_INPUT_TAIL VSS) nmos1 w=(W_NA7/max(1, W_NA7/1e-05)) l=L_NA7 m=max(1, W_NA7/1e-05) ad=(6.000000000000001e-07*((W_NA7/max(1, W_NA7/1e-05)))) as=(6.000000000000001e-07*((W_NA7/max(1, W_NA7/1e-05)))) pd=max(2*((W_NA7/max(1, W_NA7/1e-05)))+(1.2e-06),0) ps=max(2*((W_NA7/max(1, W_NA7/1e-05)))+(1.2e-06),0)
N_Mn8 (N_FOLD_L A1p N_INPUT_TAIL VSS) nmos1 w=(W_NA7/max(1, W_NA7/1e-05)) l=L_NA7 m=max(1, W_NA7/1e-05) ad=(6.000000000000001e-07*((W_NA7/max(1, W_NA7/1e-05)))) as=(6.000000000000001e-07*((W_NA7/max(1, W_NA7/1e-05)))) pd=max(2*((W_NA7/max(1, W_NA7/1e-05)))+(1.2e-06),0) ps=max(2*((W_NA7/max(1, W_NA7/1e-05)))+(1.2e-06),0)
N_Mn9 (N_INPUT_TAIL N_VB4 N_CMFB_SUM VSS) nmos1 w=(W_NA9/max(1, W_NA9/1e-05)) l=L_NA9 m=max(1, W_NA9/1e-05) ad=(6.000000000000001e-07*((W_NA9/max(1, W_NA9/1e-05)))) as=(6.000000000000001e-07*((W_NA9/max(1, W_NA9/1e-05)))) pd=max(2*((W_NA9/max(1, W_NA9/1e-05)))+(1.2000000000000004e-06),0) ps=max(2*((W_NA9/max(1, W_NA9/1e-05)))+(1.2000000000000004e-06),0)
P_Mp1 (P_PSTACK_L P_VB1 VDD VDD) pmos1 w=(W_PA1/max(1, W_PA1/1e-05)) l=L_PA1 m=max(1, W_PA1/1e-05) ad=(5.999999999999999e-07*((W_PA1/max(1, W_PA1/1e-05)))) as=(5.999999999999999e-07*((W_PA1/max(1, W_PA1/1e-05)))) pd=max(2*((W_PA1/max(1, W_PA1/1e-05)))+(1.1999999999999987e-06),0) ps=max(2*((W_PA1/max(1, W_PA1/1e-05)))+(1.1999999999999987e-06),0)
P_Mp2 (P_PSTACK_R P_VB1 VDD VDD) pmos1 w=(W_PA1/max(1, W_PA1/1e-05)) l=L_PA1 m=max(1, W_PA1/1e-05) ad=(5.999999999999999e-07*((W_PA1/max(1, W_PA1/1e-05)))) as=(5.999999999999999e-07*((W_PA1/max(1, W_PA1/1e-05)))) pd=max(2*((W_PA1/max(1, W_PA1/1e-05)))+(1.1999999999999987e-06),0) ps=max(2*((W_PA1/max(1, W_PA1/1e-05)))+(1.1999999999999987e-06),0)
P_Mp3 (POUTP P_VB2 P_PSTACK_L VDD) pmos1 w=(W_PA3/max(1, W_PA3/1e-05)) l=L_PA3 m=max(1, W_PA3/1e-05) ad=(5.999999999999999e-07*((W_PA3/max(1, W_PA3/1e-05)))) as=(5.999999999999999e-07*((W_PA3/max(1, W_PA3/1e-05)))) pd=max(2*((W_PA3/max(1, W_PA3/1e-05)))+(1.1999999999999987e-06),0) ps=max(2*((W_PA3/max(1, W_PA3/1e-05)))+(1.1999999999999987e-06),0)
P_Mp4 (POUTM P_VB2 P_PSTACK_R VDD) pmos1 w=(W_PA3/max(1, W_PA3/1e-05)) l=L_PA3 m=max(1, W_PA3/1e-05) ad=(5.999999999999999e-07*((W_PA3/max(1, W_PA3/1e-05)))) as=(5.999999999999999e-07*((W_PA3/max(1, W_PA3/1e-05)))) pd=max(2*((W_PA3/max(1, W_PA3/1e-05)))+(1.1999999999999987e-06),0) ps=max(2*((W_PA3/max(1, W_PA3/1e-05)))+(1.1999999999999987e-06),0)
P_Mp5 (P_FOLD_R B1 P_INPUT_TAIL VDD) pmos1 w=(W_PA5/max(1, W_PA5/1e-05)) l=L_PA5 m=max(1, W_PA5/1e-05) ad=(5.999999999999999e-07*((W_PA5/max(1, W_PA5/1e-05)))) as=(5.999999999999999e-07*((W_PA5/max(1, W_PA5/1e-05)))) pd=max(2*((W_PA5/max(1, W_PA5/1e-05)))+(1.1999999999999987e-06),0) ps=max(2*((W_PA5/max(1, W_PA5/1e-05)))+(1.1999999999999987e-06),0)
P_Mp6 (P_FOLD_L B1p P_INPUT_TAIL VDD) pmos1 w=(W_PA5/max(1, W_PA5/1e-05)) l=L_PA5 m=max(1, W_PA5/1e-05) ad=(5.999999999999999e-07*((W_PA5/max(1, W_PA5/1e-05)))) as=(5.999999999999999e-07*((W_PA5/max(1, W_PA5/1e-05)))) pd=max(2*((W_PA5/max(1, W_PA5/1e-05)))+(1.1999999999999987e-06),0) ps=max(2*((W_PA5/max(1, W_PA5/1e-05)))+(1.1999999999999987e-06),0)
P_Mp7 (P_CMFB_SUM POUTM VDD VDD) pmos1 w=(W_PA7/max(1, W_PA7/1e-05)) l=L_PA7 m=M_PA7*max(1, W_PA7/1e-05) ad=(5.999999999999999e-07*((W_PA7/max(1, W_PA7/1e-05)))) as=(5.999999999999999e-07*((W_PA7/max(1, W_PA7/1e-05)))) pd=max(2*((W_PA7/max(1, W_PA7/1e-05)))+(1.200000000000002e-06),0) ps=max(2*((W_PA7/max(1, W_PA7/1e-05)))+(1.200000000000002e-06),0)
P_Mp8 (P_CMFB_SUM POUTP VDD VDD) pmos1 w=(W_PA7/max(1, W_PA7/1e-05)) l=L_PA7 m=M_PA7*max(1, W_PA7/1e-05) ad=(5.999999999999999e-07*((W_PA7/max(1, W_PA7/1e-05)))) as=(5.999999999999999e-07*((W_PA7/max(1, W_PA7/1e-05)))) pd=max(2*((W_PA7/max(1, W_PA7/1e-05)))+(1.200000000000002e-06),0) ps=max(2*((W_PA7/max(1, W_PA7/1e-05)))+(1.200000000000002e-06),0)
P_Mp9 (P_INPUT_TAIL P_VB1 P_CMFB_SUM VDD) pmos1 w=(W_PA9/max(1, W_PA9/1e-05)) l=L_PA9 m=max(1, W_PA9/1e-05) ad=(6e-07*((W_PA9/max(1, W_PA9/1e-05)))) as=(6e-07*((W_PA9/max(1, W_PA9/1e-05)))) pd=max(2*((W_PA9/max(1, W_PA9/1e-05)))+(1.1999999999999987e-06),0) ps=max(2*((W_PA9/max(1, W_PA9/1e-05)))+(1.1999999999999987e-06),0)
P_Mn1 (POUTP P_VB3 P_FOLD_L VSS) nmos1 w=(W_PA_C/max(1, W_PA_C/1e-05)) l=L_PA_C m=max(1, W_PA_C/1e-05) ad=(6.000000000000001e-07*((W_PA_C/max(1, W_PA_C/1e-05)))) as=(6.000000000000001e-07*((W_PA_C/max(1, W_PA_C/1e-05)))) pd=max(2*((W_PA_C/max(1, W_PA_C/1e-05)))+(1.1999999999999997e-06),0) ps=max(2*((W_PA_C/max(1, W_PA_C/1e-05)))+(1.1999999999999997e-06),0)
P_Mn2 (POUTM P_VB3 P_FOLD_R VSS) nmos1 w=(W_PA_C/max(1, W_PA_C/1e-05)) l=L_PA_C m=max(1, W_PA_C/1e-05) ad=(6.000000000000001e-07*((W_PA_C/max(1, W_PA_C/1e-05)))) as=(6.000000000000001e-07*((W_PA_C/max(1, W_PA_C/1e-05)))) pd=max(2*((W_PA_C/max(1, W_PA_C/1e-05)))+(1.1999999999999997e-06),0) ps=max(2*((W_PA_C/max(1, W_PA_C/1e-05)))+(1.1999999999999997e-06),0)
P_Mn3 (P_FOLD_L P_VB4 VSS VSS) nmos1 w=(W_PA_S/max(1, W_PA_S/1e-05)) l=L_PA_S m=max(1, W_PA_S/1e-05) ad=(6.000000000000001e-07*((W_PA_S/max(1, W_PA_S/1e-05)))) as=(6.000000000000001e-07*((W_PA_S/max(1, W_PA_S/1e-05)))) pd=max(2*((W_PA_S/max(1, W_PA_S/1e-05)))+(1.2000000000000004e-06),0) ps=max(2*((W_PA_S/max(1, W_PA_S/1e-05)))+(1.2000000000000004e-06),0)
P_Mn4 (P_FOLD_R P_VB4 VSS VSS) nmos1 w=(W_PA_S/max(1, W_PA_S/1e-05)) l=L_PA_S m=max(1, W_PA_S/1e-05) ad=(6.000000000000001e-07*((W_PA_S/max(1, W_PA_S/1e-05)))) as=(6.000000000000001e-07*((W_PA_S/max(1, W_PA_S/1e-05)))) pd=max(2*((W_PA_S/max(1, W_PA_S/1e-05)))+(1.2000000000000004e-06),0) ps=max(2*((W_PA_S/max(1, W_PA_S/1e-05)))+(1.2000000000000004e-06),0)
ends gbfc21_dut
