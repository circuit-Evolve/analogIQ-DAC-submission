// analogiq 0.1.0 testbench - generated, do not edit
// task gbfc21_task_001  topology gbfc21
// recipe gbfc21_follower_tran_v1 v1  condition NN_T27_S1p00 (models NN, 27 C, supply 1.8 V)
// request gbfc21_task_001__plan  candidate 3a14c89e438419ec
// execution profile search_full
simulator lang=spectre
global 0
include "<CADENCE_SHARED>/FOUNDRY/analog/180nm/models/spectre/gpdk.scs" section=NN
include "dut.scs"

parameters vcm=0.8 cl=1e-12 step=0.5 vsup=1.8 vneg=0.0
// Sizing variables set in the testbench (external-bias values).
parameters I_B1={{I_B1}} I_NB1={{I_NB1}} I_NB2={{I_NB2}} I_NB3={{I_NB3}} I_NB4={{I_NB4}} I_PB1={{I_PB1}} I_PB2={{I_PB2}} I_PB3={{I_PB3}} I_PB4={{I_PB4}}
// Supplies (charged to the DUT power metrics).
VSUP (vdd 0) vsource dc=vsup
VNEG (vss 0) vsource dc=vneg
// External bias (topology external_bias; reported separately as bias power).
IB_Vb1 (b_Vb1 vss) isource dc=I_B1
MREF_Vb1 (b_Vb1 b_Vb1 vdd vdd) pmos1 w=1.8e-05 l=1.8e-07 as=((1.8e-05)*6e-07) ad=((1.8e-05)*6e-07) ps=((1.8e-05)+1.2e-06) pd=((1.8e-05)+1.2e-06)
IB_N_VB1 (b_N_VB1 vss) isource dc=I_NB1
MREF_N_VB1 (b_N_VB1 b_N_VB1 vdd vdd) pmos1 w=1.8e-06 l=1e-06 as=((1.8e-06)*6e-07) ad=((1.8e-06)*6e-07) ps=((1.8e-06)+1.2e-06) pd=((1.8e-06)+1.2e-06)
IB_N_VB2 (b_N_VB2 vss) isource dc=I_NB2
MREF_N_VB2 (b_N_VB2 b_N_VB2 vdd vdd) pmos1 w=5e-07 l=1e-06 as=((5e-07)*6e-07) ad=((5e-07)*6e-07) ps=((5e-07)+1.2e-06) pd=((5e-07)+1.2e-06)
IB_N_VB3 (vdd b_N_VB3) isource dc=I_NB3
MREF_N_VB3 (b_N_VB3 b_N_VB3 vss vss) nmos1 w=5e-07 l=1e-06 as=((5e-07)*6e-07) ad=((5e-07)*6e-07) ps=((5e-07)+1.2e-06) pd=((5e-07)+1.2e-06)
IB_N_VB4 (vdd b_N_VB4) isource dc=I_NB4
MREF_N_VB4 (b_N_VB4 b_N_VB4 vss vss) nmos1 w=9e-07 l=1e-06 as=((9e-07)*6e-07) ad=((9e-07)*6e-07) ps=((9e-07)+1.2e-06) pd=((9e-07)+1.2e-06)
IB_P_VB1 (b_P_VB1 vss) isource dc=I_PB1
MREF_P_VB1 (b_P_VB1 b_P_VB1 vdd vdd) pmos1 w=2.41e-06 l=1e-06 as=((2.41e-06)*6e-07) ad=((2.41e-06)*6e-07) ps=((2.41e-06)+1.2e-06) pd=((2.41e-06)+1.2e-06)
IB_P_VB2 (b_P_VB2 vss) isource dc=I_PB2
MREF_P_VB2 (b_P_VB2 b_P_VB2 vdd vdd) pmos1 w=5e-07 l=1e-06 as=((5e-07)*6e-07) ad=((5e-07)*6e-07) ps=((5e-07)+1.2e-06) pd=((5e-07)+1.2e-06)
IB_P_VB3 (vdd b_P_VB3) isource dc=I_PB3
MREF_P_VB3 (b_P_VB3 b_P_VB3 vss vss) nmos1 w=5e-07 l=1e-06 as=((5e-07)*6e-07) ad=((5e-07)*6e-07) ps=((5e-07)+1.2e-06) pd=((5e-07)+1.2e-06)
IB_P_VB4 (vdd b_P_VB4) isource dc=I_PB4
MREF_P_VB4 (b_P_VB4 b_P_VB4 vss vss) nmos1 w=3.4e-06 l=1e-06 as=((3.4e-06)*6e-07) ad=((3.4e-06)*6e-07) ps=((3.4e-06)+1.2e-06) pd=((3.4e-06)+1.2e-06)

// Ideal unity-gain differential follower: inputs = vcm +/- (vid - od)/2 (VCVS, no loading).
VCMI (vcmi 0) vsource dc=vcm
VID (vid 0) vsource type=pulse val0=0 val1=step delay=5e-07 rise=1e-10 fall=1e-10 width=4.999e-07 period=1e-06
EOD (od 0 out outn) vcvs gain=1
EEP (ep 0 vid od) vcvs gain=0.5
EEN (en 0 od vid) vcvs gain=0.5
EINP (inp vcmi ep 0) vcvs gain=1
EINN (inn vcmi en 0) vcvs gain=1
CL1 (out 0) capacitor c=cl
CL2 (outn 0) capacitor c=cl
VOCM (vocm 0) vsource dc=1.09

XDUT (vdd vss inn inp out outn vocm b_Vb1 b_N_VB1 b_N_VB2 b_N_VB3 b_N_VB4 b_P_VB1 b_P_VB2 b_P_VB3 b_P_VB4) gbfc21_dut L_N1={{L_N1}} L_N10={{L_N10}} L_N3={{L_N3}} L_N9={{L_N9}} L_NA1={{L_NA1}} L_NA3={{L_NA3}} L_NA5={{L_NA5}} L_NA7={{L_NA7}} L_NA9={{L_NA9}} L_NA_C={{L_NA_C}} L_NA_S={{L_NA_S}} L_P1={{L_P1}} L_P11={{L_P11}} L_P13={{L_P13}} L_P3={{L_P3}} L_P5={{L_P5}} L_P7={{L_P7}} L_P8={{L_P8}} L_PA1={{L_PA1}} L_PA3={{L_PA3}} L_PA5={{L_PA5}} L_PA7={{L_PA7}} L_PA9={{L_PA9}} L_PA_C={{L_PA_C}} L_PA_S={{L_PA_S}} M_N1={{M_N1}} M_N10={{M_N10}} M_N3={{M_N3}} M_N9={{M_N9}} M_NA1={{M_NA1}} M_NA3={{M_NA3}} M_NA5={{M_NA5}} M_NA7={{M_NA7}} M_NA9={{M_NA9}} M_NA_C={{M_NA_C}} M_NA_S={{M_NA_S}} M_P1={{M_P1}} M_P11={{M_P11}} M_P13={{M_P13}} M_P3={{M_P3}} M_P5={{M_P5}} M_P7={{M_P7}} M_P8={{M_P8}} M_PA1={{M_PA1}} M_PA3={{M_PA3}} M_PA5={{M_PA5}} M_PA7={{M_PA7}} M_PA9={{M_PA9}} M_PA_C={{M_PA_C}} M_PA_S={{M_PA_S}} W_N1={{W_N1}} W_N10={{W_N10}} W_N3={{W_N3}} W_N9={{W_N9}} W_NA1={{W_NA1}} W_NA3={{W_NA3}} W_NA5={{W_NA5}} W_NA7={{W_NA7}} W_NA9={{W_NA9}} W_NA_C={{W_NA_C}} W_NA_S={{W_NA_S}} W_P1={{W_P1}} W_P11={{W_P11}} W_P13={{W_P13}} W_P3={{W_P3}} W_P5={{W_P5}} W_P7={{W_P7}} W_P8={{W_P8}} W_PA1={{W_PA1}} W_PA3={{W_PA3}} W_PA5={{W_PA5}} W_PA7={{W_PA7}} W_PA9={{W_PA9}} W_PA_C={{W_PA_C}} W_PA_S={{W_PA_S}}

opts options temp=27.0 tnom=27 reltol=0.0001 save=selected
save VNEG:p VSUP:p inn inp od out outn vdd vid vocm vss

tr1 tran stop=1.5e-06 maxstep=5e-11 errpreset=moderate
simulator lang=spice
.include 'measures.sp'
.end
