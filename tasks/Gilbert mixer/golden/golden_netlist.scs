// Golden sizing netlist (curator 2026-10-28): the benchmark DUT subckt with its parameter defaults set to
// the golden design (golden_design.json), taken from the verified run's job tt_T27_S1p00/mixer_cg_sb_v1.
// The DUT subckt and its parameter values are the same in every job of that run (only the testbench changes).
// Instance line of that run: XDUT (vdd b_VSS ifp ifn lop lon rfp rfn b_TAIL_BIAS) gmix04_dut C_DIV=1.7671008928870212e-11 C_TAIL=6.4017835960250715e-12 C_VDD=3.955866907406885e-11 L_BB=1.9243114048022646e-07 L_SW=1.64354851593325...
// Testbench-level variables (bias sources, operating levels) are in golden_design.json and testbench decks.
// Generated by analogiq from dut_benchmark.scs (sha256 da9cdaf9df568c60).
// Connectivity and device models are unchanged except for the listed transformations:
//   - T1: mult bound to N_SW; Spectre multiplicity m follows it
//   - T1: junction geometry ad/as/pd/ps rewritten in terms of the bound width (area = Lj*W, perimeter = 2*W + c; Lj and c from the netlist)
//   - T10: mult bound to N_BB; Spectre multiplicity m follows it
//   - T10: junction geometry ad/as/pd/ps rewritten in terms of the bound width (area = Lj*W, perimeter = 2*W + c; Lj and c from the netlist)
//   - T11: mult bound to N_BB; Spectre multiplicity m follows it
//   - T11: junction geometry ad/as/pd/ps rewritten in terms of the bound width (area = Lj*W, perimeter = 2*W + c; Lj and c from the netlist)
//   - T3: mult bound to N_SW; Spectre multiplicity m follows it
//   - T3: junction geometry ad/as/pd/ps rewritten in terms of the bound width (area = Lj*W, perimeter = 2*W + c; Lj and c from the netlist)
//   - T6: mult bound to N_T; Spectre multiplicity m follows it
//   - T6: junction geometry ad/as/pd/ps rewritten in terms of the bound width (area = Lj*W, perimeter = 2*W + c; Lj and c from the netlist)
//   - T8: mult bound to N_SW; Spectre multiplicity m follows it
//   - T8: junction geometry ad/as/pd/ps rewritten in terms of the bound width (area = Lj*W, perimeter = 2*W + c; Lj and c from the netlist)
//   - T9: mult bound to N_SW; Spectre multiplicity m follows it
//   - T9: junction geometry ad/as/pd/ps rewritten in terms of the bound width (area = Lj*W, perimeter = 2*W + c; Lj and c from the netlist)
//   - netlist parameters bound to sizing variables: W_BB <- W_BB, W_SW <- W_SW, W_T <- W_T
subckt gmix04_dut (VDD VSS RF_P RF_N LO_P LO_N BB_P BB_N TAIL_BIAS)
parameters W_SW=1.18998834999351e-06 L_SW=1.643548515933251e-07 NF_SW=40.0 N_SW=7.0 W_BB=1.0834419975758535e-06 L_BB=1.9243114048022646e-07 NF_BB=35.0 N_BB=4.0 W_T=1.8388871128264066e-06 L_T=1.7157063295728973e-07 NF_T=35.0 N_T=6.0 R_D=95.0411223204154 R_DIV_TOP=3312.20785948124 R_DIV_BOT=13308.583612898425 R_BB=961.5728300253633 C_DIV=1.7671008928870212e-11 C_VDD=3.955866907406885e-11 C_TAIL=6.4017835960250715e-12
CV0 (BIAS_DIV VSS) capacitor c=C_DIV
CV1 (VDD VSS) capacitor c=C_VDD
CV2 (TAIL_BIAS VSS) capacitor c=C_TAIL
RP0 (BIAS_DIV VSS) resistor r=R_DIV_BOT
RP1 (VDD BIAS_DIV) resistor r=R_DIV_TOP
RP2 (BB_P BIAS_DIV) resistor r=R_BB
RP3 (BB_N BIAS_DIV) resistor r=R_BB
T1 (RF_P LO_P X_P VSS) sky130_fd_pr__nfet_01v8 w=((W_SW*NF_SW)/1e-06) l=(L_SW/1e-06) nf=NF_SW mult=N_SW ad=(0.145*(((W_SW*NF_SW)/1e-06))) as=(0.1595*(((W_SW*NF_SW)/1e-06))) pd=max(2*(((W_SW*NF_SW)/1e-06))+(-14.2),0) ps=max(2*(((W_SW*NF_SW)/1e-06))+(-11.620000000000001),0) sa=0 sb=0 sd=0 m=N_SW
T10 (X_N BB_N TAIL VSS) sky130_fd_pr__nfet_01v8 w=((W_BB*NF_BB)/1e-06) l=(L_BB/1e-06) nf=NF_BB mult=N_BB ad=(0.145*(((W_BB*NF_BB)/1e-06))) as=(0.15466666666666665*(((W_BB*NF_BB)/1e-06))) pd=max(2*(((W_BB*NF_BB)/1e-06))+(-21.299999999999997),0) ps=max(2*(((W_BB*NF_BB)/1e-06))+(-18.72),0) sa=0 sb=0 sd=0 m=N_BB
T11 (X_P BB_P TAIL VSS) sky130_fd_pr__nfet_01v8 w=((W_BB*NF_BB)/1e-06) l=(L_BB/1e-06) nf=NF_BB mult=N_BB ad=(0.145*(((W_BB*NF_BB)/1e-06))) as=(0.15466666666666665*(((W_BB*NF_BB)/1e-06))) pd=max(2*(((W_BB*NF_BB)/1e-06))+(-21.299999999999997),0) ps=max(2*(((W_BB*NF_BB)/1e-06))+(-18.72),0) sa=0 sb=0 sd=0 m=N_BB
T3 (RF_N LO_N X_P VSS) sky130_fd_pr__nfet_01v8 w=((W_SW*NF_SW)/1e-06) l=(L_SW/1e-06) nf=NF_SW mult=N_SW ad=(0.145*(((W_SW*NF_SW)/1e-06))) as=(0.1595*(((W_SW*NF_SW)/1e-06))) pd=max(2*(((W_SW*NF_SW)/1e-06))+(-14.2),0) ps=max(2*(((W_SW*NF_SW)/1e-06))+(-11.620000000000001),0) sa=0 sb=0 sd=0 m=N_SW
T6 (TAIL TAIL_BIAS VSS VSS) sky130_fd_pr__nfet_01v8 w=((W_T*NF_T)/1e-06) l=(L_T/1e-06) nf=NF_T mult=N_T ad=(0.145*(((W_T*NF_T)/1e-06))) as=(0.1508*(((W_T*NF_T)/1e-06))) pd=max(2*(((W_T*NF_T)/1e-06))+(-85.5),0) ps=max(2*(((W_T*NF_T)/1e-06))+(-80.92),0) sa=0 sb=0 sd=0 m=N_T
T8 (RF_P LO_N X_N VSS) sky130_fd_pr__nfet_01v8 w=((W_SW*NF_SW)/1e-06) l=(L_SW/1e-06) nf=NF_SW mult=N_SW ad=(0.145*(((W_SW*NF_SW)/1e-06))) as=(0.1595*(((W_SW*NF_SW)/1e-06))) pd=max(2*(((W_SW*NF_SW)/1e-06))+(-14.2),0) ps=max(2*(((W_SW*NF_SW)/1e-06))+(-11.620000000000001),0) sa=0 sb=0 sd=0 m=N_SW
T9 (RF_N LO_P X_N VSS) sky130_fd_pr__nfet_01v8 w=((W_SW*NF_SW)/1e-06) l=(L_SW/1e-06) nf=NF_SW mult=N_SW ad=(0.145*(((W_SW*NF_SW)/1e-06))) as=(0.1595*(((W_SW*NF_SW)/1e-06))) pd=max(2*(((W_SW*NF_SW)/1e-06))+(-14.2),0) ps=max(2*(((W_SW*NF_SW)/1e-06))+(-11.620000000000001),0) sa=0 sb=0 sd=0 m=N_SW
RD_P (VDD RF_P) resistor r=R_D
RD_N (VDD RF_N) resistor r=R_D
ends gmix04_dut
