// analogiq 0.1.0 testbench - generated, do not edit
// task gmix04_task_001  topology gmix04_patulea_2015
// recipe mixer_p1db_sb_v1 v1  condition tt_T27_S1p00 (models tt, 27 C, supply 1.8 V)
// request gmix04_task_001__plan  candidate 4ebbce2762a48315
// execution profile search_full
simulator lang=spectre
global 0
include "<PDK_ROOT>/sky130_cds/spectre/libs.tech/combined/sky130.lib.spice" section=tt
include "dut.scs"

parameters pin=-30.0 vsup=1.8
// Sizing variables set in the testbench (external-bias values).
parameters V_LO={{V_LO}} V_TAIL={{V_TAIL}}
// Supplies (charged to the DUT power metrics).
VSUP (vdd 0) vsource dc=vsup
// External bias (topology external_bias; reported separately as bias power).
VB_VSS (b_VSS 0) vsource dc=0.0
VB_TAIL_BIAS (b_TAIL_BIAS 0) vsource dc=V_TAIL

// Ideal LO drive (large signal).
VLOP (lop 0) vsource type=sine sinedc=V_LO ampl=0.34 freq=5000000000.0 fundname="lo"
VLON (lon 0) vsource type=sine sinedc=V_LO ampl=0.34 freq=5000000000.0 sinephase=180 fundname="lo"
// RF: matched port, noiseless termination, ideal balun AC-coupled through ideal DC blocks (instrumentation).
PRF (rfi 0) port r=50.0 num=1 type=sine freq=20000000.0 dbm=pin fundname="rf"
RT (rfi 0) resistor r=50.0 isnoisy=no
ERP (rfsp 0 rfi 0) vcvs gain=0.5
ERN (rfsn 0 rfi 0) vcvs gain=-0.5
CBP (rfsp rfp) capacitor c=1e-08
CBN (rfsn rfn) capacitor c=1e-08
EIF (vif 0 ifp ifn) vcvs gain=1

XDUT (vdd b_VSS ifp ifn lop lon rfp rfn b_TAIL_BIAS) gmix04_dut C_DIV={{C_DIV}} C_TAIL={{C_TAIL}} C_VDD={{C_VDD}} L_BB={{L_BB}} L_SW={{L_SW}} L_T={{L_T}} NF_BB={{NF_BB}} NF_SW={{NF_SW}} NF_T={{NF_T}} N_BB={{N_BB}} N_SW={{N_SW}} N_T={{N_T}} R_BB={{R_BB}} R_D={{R_D}} R_DIV_BOT={{R_DIV_BOT}} R_DIV_TOP={{R_DIV_TOP}} W_BB={{W_BB}} W_SW={{W_SW}} W_T={{W_T}}

opts options temp=27.0 tnom=27 reltol=0.0001 save=selected
save VB_TAIL_BIAS:p VB_VSS:p VSUP:p ifn ifp lon lop rfn rfp vdd vif

swp sweep param=pin start=-30.0 stop=6.0 step=1.0 {
hb1 hb funds=["lo" "rf"] maxharms=[7 3] errpreset=moderate
}
