// Generated by analogiq from final.scs (sha256 924a793260310aa9).
// Connectivity and device models are unchanged except for the listed transformations:
//   - ota_fig2_interpreted.M1: junction geometry as/ad/ps/pd rewritten in terms of the bound width (area = Lj*W, perimeter = 2*W + c; Lj and c from the netlist)
//   - ota_fig2_interpreted.M2: junction geometry as/ad/ps/pd rewritten in terms of the bound width (area = Lj*W, perimeter = 2*W + c; Lj and c from the netlist)
//   - ota_fig2_interpreted.M3: junction geometry as/ad/ps/pd rewritten in terms of the bound width (area = Lj*W, perimeter = 2*W + c; Lj and c from the netlist)
//   - ota_fig2_interpreted.M4: junction geometry as/ad/ps/pd rewritten in terms of the bound width (area = Lj*W, perimeter = 2*W + c; Lj and c from the netlist)
//   - ota_fig2_interpreted.M5: junction geometry as/ad/ps/pd rewritten in terms of the bound width (area = Lj*W, perimeter = 2*W + c; Lj and c from the netlist)
//   - ota_fig2_interpreted.M6: junction geometry as/ad/ps/pd rewritten in terms of the bound width (area = Lj*W, perimeter = 2*W + c; Lj and c from the netlist)
//   - ota_fig2_interpreted.M7: junction geometry as/ad/ps/pd rewritten in terms of the bound width (area = Lj*W, perimeter = 2*W + c; Lj and c from the netlist)
//   - ota_fig2_interpreted.M8: junction geometry as/ad/ps/pd rewritten in terms of the bound width (area = Lj*W, perimeter = 2*W + c; Lj and c from the netlist)
//   - ota_fig2_interpreted.M9: junction geometry as/ad/ps/pd rewritten in terms of the bound width (area = Lj*W, perimeter = 2*W + c; Lj and c from the netlist)
//   - ota_fig2_interpreted.M10: junction geometry as/ad/ps/pd rewritten in terms of the bound width (area = Lj*W, perimeter = 2*W + c; Lj and c from the netlist)
//   - ota_fig2_interpreted.M11: junction geometry as/ad/ps/pd rewritten in terms of the bound width (area = Lj*W, perimeter = 2*W + c; Lj and c from the netlist)
//   - ota_fig2_interpreted.M12: junction geometry as/ad/ps/pd rewritten in terms of the bound width (area = Lj*W, perimeter = 2*W + c; Lj and c from the netlist)
//   - ota_fig2_interpreted.M13: junction geometry as/ad/ps/pd rewritten in terms of the bound width (area = Lj*W, perimeter = 2*W + c; Lj and c from the netlist)
//   - ota_fig2_interpreted.M14: junction geometry as/ad/ps/pd rewritten in terms of the bound width (area = Lj*W, perimeter = 2*W + c; Lj and c from the netlist)
//   - ota_fig2_interpreted.M15: junction geometry as/ad/ps/pd rewritten in terms of the bound width (area = Lj*W, perimeter = 2*W + c; Lj and c from the netlist)
//   - ota_fig2_interpreted.M16: junction geometry as/ad/ps/pd rewritten in terms of the bound width (area = Lj*W, perimeter = 2*W + c; Lj and c from the netlist)
//   - ota_fig2_interpreted.M17: junction geometry as/ad/ps/pd rewritten in terms of the bound width (area = Lj*W, perimeter = 2*W + c; Lj and c from the netlist)
//   - ota_fig2_interpreted.M18: junction geometry as/ad/ps/pd rewritten in terms of the bound width (area = Lj*W, perimeter = 2*W + c; Lj and c from the netlist)
//   - ota_fig2_interpreted.M19: junction geometry as/ad/ps/pd rewritten in terms of the bound width (area = Lj*W, perimeter = 2*W + c; Lj and c from the netlist)
//   - ota_fig2_interpreted.M20: junction geometry as/ad/ps/pd rewritten in terms of the bound width (area = Lj*W, perimeter = 2*W + c; Lj and c from the netlist)
//   - ota_fig2_interpreted.M21: junction geometry as/ad/ps/pd rewritten in terms of the bound width (area = Lj*W, perimeter = 2*W + c; Lj and c from the netlist)
//   - ota_fig2_interpreted.M22: junction geometry as/ad/ps/pd rewritten in terms of the bound width (area = Lj*W, perimeter = 2*W + c; Lj and c from the netlist)
//   - ota_fig2_interpreted.M23: junction geometry as/ad/ps/pd rewritten in terms of the bound width (area = Lj*W, perimeter = 2*W + c; Lj and c from the netlist)
//   - ota_fig2_interpreted.M24: junction geometry as/ad/ps/pd rewritten in terms of the bound width (area = Lj*W, perimeter = 2*W + c; Lj and c from the netlist)
//   - ota_fig2_interpreted.M25: junction geometry as/ad/ps/pd rewritten in terms of the bound width (area = Lj*W, perimeter = 2*W + c; Lj and c from the netlist)
//   - ota_fig2_interpreted.M26: junction geometry as/ad/ps/pd rewritten in terms of the bound width (area = Lj*W, perimeter = 2*W + c; Lj and c from the netlist)
//   - ota_fig2_interpreted.M27: junction geometry as/ad/ps/pd rewritten in terms of the bound width (area = Lj*W, perimeter = 2*W + c; Lj and c from the netlist)
//   - ota_fig2_interpreted.M28: junction geometry as/ad/ps/pd rewritten in terms of the bound width (area = Lj*W, perimeter = 2*W + c; Lj and c from the netlist)
//   - ota_fig2_interpreted.M25R: junction geometry as/ad/ps/pd rewritten in terms of the bound width (area = Lj*W, perimeter = 2*W + c; Lj and c from the netlist)
//   - ota_fig2_interpreted.M26R: junction geometry as/ad/ps/pd rewritten in terms of the bound width (area = Lj*W, perimeter = 2*W + c; Lj and c from the netlist)
//   - ota_fig2_interpreted.M27R: junction geometry as/ad/ps/pd rewritten in terms of the bound width (area = Lj*W, perimeter = 2*W + c; Lj and c from the netlist)
//   - ota_fig2_interpreted.M28R: junction geometry as/ad/ps/pd rewritten in terms of the bound width (area = Lj*W, perimeter = 2*W + c; Lj and c from the netlist)
//   - FD1Pn: junction geometry as/ad/ps/pd rewritten in terms of the bound width (area = Lj*W, perimeter = 2*W + c; Lj and c from the netlist)
//   - FD1Pp: junction geometry as/ad/ps/pd rewritten in terms of the bound width (area = Lj*W, perimeter = 2*W + c; Lj and c from the netlist)
//   - FD1Mn: junction geometry as/ad/ps/pd rewritten in terms of the bound width (area = Lj*W, perimeter = 2*W + c; Lj and c from the netlist)
//   - FD1Mp: junction geometry as/ad/ps/pd rewritten in terms of the bound width (area = Lj*W, perimeter = 2*W + c; Lj and c from the netlist)
//   - FD2Pn: junction geometry as/ad/ps/pd rewritten in terms of the bound width (area = Lj*W, perimeter = 2*W + c; Lj and c from the netlist)
//   - FD2Pp: junction geometry as/ad/ps/pd rewritten in terms of the bound width (area = Lj*W, perimeter = 2*W + c; Lj and c from the netlist)
//   - FD2Mn: junction geometry as/ad/ps/pd rewritten in terms of the bound width (area = Lj*W, perimeter = 2*W + c; Lj and c from the netlist)
//   - FD2Mp: junction geometry as/ad/ps/pd rewritten in terms of the bound width (area = Lj*W, perimeter = 2*W + c; Lj and c from the netlist)
//   - FD3Pn: junction geometry as/ad/ps/pd rewritten in terms of the bound width (area = Lj*W, perimeter = 2*W + c; Lj and c from the netlist)
//   - FD3Pp: junction geometry as/ad/ps/pd rewritten in terms of the bound width (area = Lj*W, perimeter = 2*W + c; Lj and c from the netlist)
//   - FD3Mn: junction geometry as/ad/ps/pd rewritten in terms of the bound width (area = Lj*W, perimeter = 2*W + c; Lj and c from the netlist)
//   - FD3Mp: junction geometry as/ad/ps/pd rewritten in terms of the bound width (area = Lj*W, perimeter = 2*W + c; Lj and c from the netlist)
//   - FD4Pn: junction geometry as/ad/ps/pd rewritten in terms of the bound width (area = Lj*W, perimeter = 2*W + c; Lj and c from the netlist)
//   - FD4Pp: junction geometry as/ad/ps/pd rewritten in terms of the bound width (area = Lj*W, perimeter = 2*W + c; Lj and c from the netlist)
//   - FD4Mn: junction geometry as/ad/ps/pd rewritten in terms of the bound width (area = Lj*W, perimeter = 2*W + c; Lj and c from the netlist)
//   - FD4Mp: junction geometry as/ad/ps/pd rewritten in terms of the bound width (area = Lj*W, perimeter = 2*W + c; Lj and c from the netlist)
//   - sizing variables bound inside local subckts are subckt parameters passed from the DUT instance(s): ota_fig2_interpreted: ['M19_l', 'M19_m', 'M19_w', 'M20_l', 'M20_m', 'M20_w', 'M23_l', 'M23_m', 'M23_w', 'M24_l', 'M24_m', 'M24_w', 'M25_l', 'M25_m', 'M25_w', 'M28_l', 'M28_m', 'M28_w', 'bias_n_l', 'bias_n_m', 'bias_n_w', 'bias_p_l', 'bias_p_m', 'bias_p_w', 'cm_fb_n_l', 'cm_fb_n_m', 'cm_fb_n_w', 'cm_fb_p_l', 'cm_fb_p_m', 'cm_fb_p_w', 'cm_node_n_l', 'cm_node_n_m', 'cm_node_n_w', 'cm_node_p_l', 'cm_node_p_m', 'cm_node_p_w', 'cm_out_n_l', 'cm_out_n_m', 'cm_out_n_w', 'cm_out_p_l', 'cm_out_p_m', 'cm_out_p_w', 'cross_n_l', 'cross_n_m', 'cross_n_w', 'cross_p_l', 'cross_p_m', 'cross_p_w', 'input_n_l', 'input_n_m', 'input_n_w', 'input_p_l', 'input_p_m', 'input_p_w', 'load_n_l', 'load_n_m', 'load_n_w', 'load_p_l', 'load_p_m', 'load_p_w']
subckt ota_fig2_interpreted (VIP VIM VOP VOM VT VREF VDD GND)
  parameters M19_l=1e-06 M19_m=1.0 M19_w=1e-06 M20_l=1e-06 M20_m=1.0 M20_w=1e-06 M23_l=1e-06 M23_m=1.0 M23_w=1e-06 M24_l=1e-06 M24_m=1.0 M24_w=1e-06 M25_l=1e-06 M25_m=1.0 M25_w=1e-06 M28_l=1e-06 M28_m=1.0 M28_w=1e-06 bias_n_l=1e-06 bias_n_m=1.0 bias_n_w=1e-06 bias_p_l=1e-06 bias_p_m=1.0 bias_p_w=1e-06 cm_fb_n_l=1e-06 cm_fb_n_m=1.0 cm_fb_n_w=1e-06 cm_fb_p_l=1e-06 cm_fb_p_m=1.0 cm_fb_p_w=1e-06 cm_node_n_l=1e-06 cm_node_n_m=1.0 cm_node_n_w=1e-06 cm_node_p_l=1e-06 cm_node_p_m=1.0 cm_node_p_w=1e-06 cm_out_n_l=1e-06 cm_out_n_m=1.0 cm_out_n_w=1e-06 cm_out_p_l=1e-06 cm_out_p_m=1.0 cm_out_p_w=1e-06 cross_n_l=1e-06 cross_n_m=1.0 cross_n_w=1e-06 cross_p_l=1e-06 cross_p_m=1.0 cross_p_w=1e-06 input_n_l=1e-06 input_n_m=1.0 input_n_w=1e-06 input_p_l=1e-06 input_p_m=1.0 input_p_w=1e-06 load_n_l=1e-06 load_n_m=1.0 load_n_w=1e-06 load_p_l=1e-06 load_p_m=1.0 load_p_w=1e-06
  M1 (VOM VIP VDD VDD) gpdk090_pmos1v w=input_p_w l=input_p_l m=input_p_m as=(2.8e-07*(input_p_w)) ad=(2.8e-07*(input_p_w)) ps=max(2*(input_p_w)+(5.600000000000001e-07),0) pd=max(2*(input_p_w)+(5.600000000000001e-07),0)
  M2 (VOM VIP GND GND) gpdk090_nmos1v w=input_n_w l=input_n_l m=input_n_m as=(2.8e-07*(input_n_w)) ad=(2.8e-07*(input_n_w)) ps=max(2*(input_n_w)+(5.600000000000001e-07),0) pd=max(2*(input_n_w)+(5.600000000000001e-07),0)
  M3 (VOP VIM VDD VDD) gpdk090_pmos1v w=input_p_w l=input_p_l m=input_p_m as=(2.8e-07*(input_p_w)) ad=(2.8e-07*(input_p_w)) ps=max(2*(input_p_w)+(5.600000000000001e-07),0) pd=max(2*(input_p_w)+(5.600000000000001e-07),0)
  M4 (VOP VIM GND GND) gpdk090_nmos1v w=input_n_w l=input_n_l m=input_n_m as=(2.8e-07*(input_n_w)) ad=(2.8e-07*(input_n_w)) ps=max(2*(input_n_w)+(5.600000000000001e-07),0) pd=max(2*(input_n_w)+(5.600000000000001e-07),0)
  M5 (VOP VOM GND GND) gpdk090_nmos1v w=cross_n_w l=cross_n_l m=cross_n_m as=(2.8e-07*(cross_n_w)) ad=(2.8e-07*(cross_n_w)) ps=max(2*(cross_n_w)+(5.600000000000001e-07),0) pd=max(2*(cross_n_w)+(5.600000000000001e-07),0)
  M6 (VOP VOM VDD VDD) gpdk090_pmos1v w=cross_p_w l=cross_p_l m=cross_p_m as=(2.8e-07*(cross_p_w)) ad=(2.8e-07*(cross_p_w)) ps=max(2*(cross_p_w)+(5.600000000000001e-07),0) pd=max(2*(cross_p_w)+(5.600000000000001e-07),0)
  M7 (VOP BN GND GND) gpdk090_nmos1v w=load_n_w l=load_n_l m=load_n_m as=(2.8e-07*(load_n_w)) ad=(2.8e-07*(load_n_w)) ps=max(2*(load_n_w)+(5.600000000000001e-07),0) pd=max(2*(load_n_w)+(5.600000000000001e-07),0)
  M8 (VOP BP VDD VDD) gpdk090_pmos1v w=load_p_w l=load_p_l m=load_p_m as=(2.8e-07*(load_p_w)) ad=(2.8e-07*(load_p_w)) ps=max(2*(load_p_w)+(5.600000000000001e-07),0) pd=max(2*(load_p_w)+(5.600000000000001e-07),0)
  M9 (VOM VOP GND GND) gpdk090_nmos1v w=cross_n_w l=cross_n_l m=cross_n_m as=(2.8e-07*(cross_n_w)) ad=(2.8e-07*(cross_n_w)) ps=max(2*(cross_n_w)+(5.600000000000001e-07),0) pd=max(2*(cross_n_w)+(5.600000000000001e-07),0)
  M10 (VOM VOP VDD VDD) gpdk090_pmos1v w=cross_p_w l=cross_p_l m=cross_p_m as=(2.8e-07*(cross_p_w)) ad=(2.8e-07*(cross_p_w)) ps=max(2*(cross_p_w)+(5.600000000000001e-07),0) pd=max(2*(cross_p_w)+(5.600000000000001e-07),0)
  M11 (VOM BN GND GND) gpdk090_nmos1v w=load_n_w l=load_n_l m=load_n_m as=(2.8e-07*(load_n_w)) ad=(2.8e-07*(load_n_w)) ps=max(2*(load_n_w)+(5.600000000000001e-07),0) pd=max(2*(load_n_w)+(5.600000000000001e-07),0)
  M12 (VOM BP VDD VDD) gpdk090_pmos1v w=load_p_w l=load_p_l m=load_p_m as=(2.8e-07*(load_p_w)) ad=(2.8e-07*(load_p_w)) ps=max(2*(load_p_w)+(5.600000000000001e-07),0) pd=max(2*(load_p_w)+(5.600000000000001e-07),0)
  M13 (VOM N GND GND) gpdk090_nmos1v w=cm_out_n_w l=cm_out_n_l m=cm_out_n_m as=(2.8e-07*(cm_out_n_w)) ad=(2.8e-07*(cm_out_n_w)) ps=max(2*(cm_out_n_w)+(5.600000000000001e-07),0) pd=max(2*(cm_out_n_w)+(5.600000000000001e-07),0)
  M14 (VOM N VDD VDD) gpdk090_pmos1v w=cm_out_p_w l=cm_out_p_l m=cm_out_p_m as=(2.8e-07*(cm_out_p_w)) ad=(2.8e-07*(cm_out_p_w)) ps=max(2*(cm_out_p_w)+(5.600000000000001e-07),0) pd=max(2*(cm_out_p_w)+(5.600000000000001e-07),0)
  M15 (VOP N GND GND) gpdk090_nmos1v w=cm_out_n_w l=cm_out_n_l m=cm_out_n_m as=(2.8e-07*(cm_out_n_w)) ad=(2.8e-07*(cm_out_n_w)) ps=max(2*(cm_out_n_w)+(5.600000000000001e-07),0) pd=max(2*(cm_out_n_w)+(5.600000000000001e-07),0)
  M16 (VOP N VDD VDD) gpdk090_pmos1v w=cm_out_p_w l=cm_out_p_l m=cm_out_p_m as=(2.8e-07*(cm_out_p_w)) ad=(2.8e-07*(cm_out_p_w)) ps=max(2*(cm_out_p_w)+(5.600000000000001e-07),0) pd=max(2*(cm_out_p_w)+(5.600000000000001e-07),0)
  M17 (N N GND GND) gpdk090_nmos1v w=cm_node_n_w l=cm_node_n_l m=cm_node_n_m as=(2.8e-07*(cm_node_n_w)) ad=(2.8e-07*(cm_node_n_w)) ps=max(2*(cm_node_n_w)+(5.600000000000001e-07),0) pd=max(2*(cm_node_n_w)+(5.600000000000001e-07),0)
  M18 (N N VDD VDD) gpdk090_pmos1v w=cm_node_p_w l=cm_node_p_l m=cm_node_p_m as=(2.8e-07*(cm_node_p_w)) ad=(2.8e-07*(cm_node_p_w)) ps=max(2*(cm_node_p_w)+(5.600000000000001e-07),0) pd=max(2*(cm_node_p_w)+(5.600000000000001e-07),0)
  M19 (N VIP GND GND) gpdk090_nmos1v w=M19_w l=M19_l m=M19_m as=(2.8e-07*(M19_w)) ad=(2.8e-07*(M19_w)) ps=max(2*(M19_w)+(5.600000000000001e-07),0) pd=max(2*(M19_w)+(5.600000000000001e-07),0)
  M20 (N VIM VDD VDD) gpdk090_pmos1v w=M20_w l=M20_l m=M20_m as=(2.8e-07*(M20_w)) ad=(2.8e-07*(M20_w)) ps=max(2*(M20_w)+(5.600000000000001e-07),0) pd=max(2*(M20_w)+(5.600000000000001e-07),0)
  M21 (FB VOM GND GND) gpdk090_nmos1v w=cm_fb_n_w l=cm_fb_n_l m=cm_fb_n_m as=(2.8e-07*(cm_fb_n_w)) ad=(2.8e-07*(cm_fb_n_w)) ps=max(2*(cm_fb_n_w)+(5.600000000000001e-07),0) pd=max(2*(cm_fb_n_w)+(5.600000000000001e-07),0)
  M22 (FB VOP VDD VDD) gpdk090_pmos1v w=cm_fb_p_w l=cm_fb_p_l m=cm_fb_p_m as=(2.8e-07*(cm_fb_p_w)) ad=(2.8e-07*(cm_fb_p_w)) ps=max(2*(cm_fb_p_w)+(5.600000000000001e-07),0) pd=max(2*(cm_fb_p_w)+(5.600000000000001e-07),0)
  M23 (N VREF GND GND) gpdk090_nmos1v w=M23_w l=M23_l m=M23_m as=(2.8e-07*(M23_w)) ad=(2.8e-07*(M23_w)) ps=max(2*(M23_w)+(5.600000000000001e-07),0) pd=max(2*(M23_w)+(5.600000000000001e-07),0)
  M24 (N FB VDD VDD) gpdk090_pmos1v w=M24_w l=M24_l m=M24_m as=(2.8e-07*(M24_w)) ad=(2.8e-07*(M24_w)) ps=max(2*(M24_w)+(5.600000000000001e-07),0) pd=max(2*(M24_w)+(5.600000000000001e-07),0)
  M25 (BP VT GND GND) gpdk090_nmos1v w=M25_w l=M25_l m=M25_m as=(2.8e-07*(M25_w)) ad=(2.8e-07*(M25_w)) ps=max(2*(M25_w)+(5.600000000000001e-07),0) pd=max(2*(M25_w)+(5.600000000000001e-07),0)
  M26 (BN BN GND GND) gpdk090_nmos1v w=bias_n_w l=bias_n_l m=bias_n_m as=(2.8e-07*(bias_n_w)) ad=(2.8e-07*(bias_n_w)) ps=max(2*(bias_n_w)+(5.600000000000001e-07),0) pd=max(2*(bias_n_w)+(5.600000000000001e-07),0)
  M27 (BP BP VDD VDD) gpdk090_pmos1v w=bias_p_w l=bias_p_l m=bias_p_m as=(2.8e-07*(bias_p_w)) ad=(2.8e-07*(bias_p_w)) ps=max(2*(bias_p_w)+(5.600000000000001e-07),0) pd=max(2*(bias_p_w)+(5.600000000000001e-07),0)
  M28 (BN BP VDD VDD) gpdk090_pmos1v w=M28_w l=M28_l m=M28_m as=(2.8e-07*(M28_w)) ad=(2.8e-07*(M28_w)) ps=max(2*(M28_w)+(5.600000000000001e-07),0) pd=max(2*(M28_w)+(5.600000000000001e-07),0)
  M25R (N N VDD VDD) gpdk090_pmos1v w=cm_node_p_w l=cm_node_p_l m=cm_node_p_m as=(2.8e-07*(cm_node_p_w)) ad=(2.8e-07*(cm_node_p_w)) ps=max(2*(cm_node_p_w)+(5.600000000000001e-07),0) pd=max(2*(cm_node_p_w)+(5.600000000000001e-07),0)
  M26R (N N GND GND) gpdk090_nmos1v w=cm_node_n_w l=cm_node_n_l m=cm_node_n_m as=(2.8e-07*(cm_node_n_w)) ad=(2.8e-07*(cm_node_n_w)) ps=max(2*(cm_node_n_w)+(5.600000000000001e-07),0) pd=max(2*(cm_node_n_w)+(5.600000000000001e-07),0)
  M27R (N N VDD VDD) gpdk090_pmos1v w=cm_node_p_w l=cm_node_p_l m=cm_node_p_m as=(2.8e-07*(cm_node_p_w)) ad=(2.8e-07*(cm_node_p_w)) ps=max(2*(cm_node_p_w)+(5.600000000000001e-07),0) pd=max(2*(cm_node_p_w)+(5.600000000000001e-07),0)
  M28R (N N GND GND) gpdk090_nmos1v w=cm_node_n_w l=cm_node_n_l m=cm_node_n_m as=(2.8e-07*(cm_node_n_w)) ad=(2.8e-07*(cm_node_n_w)) ps=max(2*(cm_node_n_w)+(5.600000000000001e-07),0) pd=max(2*(cm_node_n_w)+(5.600000000000001e-07),0)
ends ota_fig2_interpreted
subckt gmc_filter (VIP VIM VOP VOM VT VREF VDD GND)
parameters input_p_w=1e-06 input_p_l=1e-06 input_p_m=1.0 input_n_w=1e-06 input_n_l=1e-06 input_n_m=1.0 cross_n_w=1e-06 cross_n_l=1e-06 cross_n_m=1.0 cross_p_w=1e-06 cross_p_l=1e-06 cross_p_m=1.0 load_n_w=1e-06 load_n_l=1e-06 load_n_m=1.0 load_p_w=1e-06 load_p_l=1e-06 load_p_m=1.0 cm_out_n_w=1e-06 cm_out_n_l=1e-06 cm_out_n_m=1.0 cm_out_p_w=1e-06 cm_out_p_l=1e-06 cm_out_p_m=1.0 cm_node_n_w=1e-06 cm_node_n_l=1e-06 cm_node_n_m=1.0 cm_node_p_w=1e-06 cm_node_p_l=1e-06 cm_node_p_m=1.0 cm_fb_n_w=1e-06 cm_fb_n_l=1e-06 cm_fb_n_m=1.0 cm_fb_p_w=1e-06 cm_fb_p_l=1e-06 cm_fb_p_m=1.0 bias_n_w=1e-06 bias_n_l=1e-06 bias_n_m=1.0 bias_p_w=1e-06 bias_p_l=1e-06 bias_p_m=1.0 M19_w=1e-06 M19_l=1e-06 M19_m=1.0 M20_w=1e-06 M20_l=1e-06 M20_m=1.0 M23_w=1e-06 M23_l=1e-06 M23_m=1.0 M24_w=1e-06 M24_l=1e-06 M24_m=1.0 M25_w=1e-06 M25_l=1e-06 M25_m=1.0 M28_w=1e-06 M28_l=1e-06 M28_m=1.0 feedback_n_w=1e-06 feedback_n_l=1e-06 feedback_n_m=1.0 feedback_p_w=1e-06 feedback_p_l=1e-06 feedback_p_m=1.0 cap_b_F=1e-12 cap_d_F=1e-12
OTA1 (VIP VIM AP AM VT VREF VDD GND) ota_fig2_interpreted M19_l=M19_l M19_m=M19_m M19_w=M19_w M20_l=M20_l M20_m=M20_m M20_w=M20_w M23_l=M23_l M23_m=M23_m M23_w=M23_w M24_l=M24_l M24_m=M24_m M24_w=M24_w M25_l=M25_l M25_m=M25_m M25_w=M25_w M28_l=M28_l M28_m=M28_m M28_w=M28_w bias_n_l=bias_n_l bias_n_m=bias_n_m bias_n_w=bias_n_w bias_p_l=bias_p_l bias_p_m=bias_p_m bias_p_w=bias_p_w cm_fb_n_l=cm_fb_n_l cm_fb_n_m=cm_fb_n_m cm_fb_n_w=cm_fb_n_w cm_fb_p_l=cm_fb_p_l cm_fb_p_m=cm_fb_p_m cm_fb_p_w=cm_fb_p_w cm_node_n_l=cm_node_n_l cm_node_n_m=cm_node_n_m cm_node_n_w=cm_node_n_w cm_node_p_l=cm_node_p_l cm_node_p_m=cm_node_p_m cm_node_p_w=cm_node_p_w cm_out_n_l=cm_out_n_l cm_out_n_m=cm_out_n_m cm_out_n_w=cm_out_n_w cm_out_p_l=cm_out_p_l cm_out_p_m=cm_out_p_m cm_out_p_w=cm_out_p_w cross_n_l=cross_n_l cross_n_m=cross_n_m cross_n_w=cross_n_w cross_p_l=cross_p_l cross_p_m=cross_p_m cross_p_w=cross_p_w input_n_l=input_n_l input_n_m=input_n_m input_n_w=input_n_w input_p_l=input_p_l input_p_m=input_p_m input_p_w=input_p_w load_n_l=load_n_l load_n_m=load_n_m load_n_w=load_n_w load_p_l=load_p_l load_p_m=load_p_m load_p_w=load_p_w
C1 (AP AM) capacitor c=cap_b_F
FD1Pn (AP AP GND GND) gpdk090_nmos1v w=feedback_n_w l=feedback_n_l m=feedback_n_m as=(2.8e-07*(feedback_n_w)) ad=(2.8e-07*(feedback_n_w)) ps=max(2*(feedback_n_w)+(5.600000000000001e-07),0) pd=max(2*(feedback_n_w)+(5.600000000000001e-07),0)
FD1Pp (AP AP VDD VDD) gpdk090_pmos1v w=feedback_p_w l=feedback_p_l m=feedback_p_m as=(2.8e-07*(feedback_p_w)) ad=(2.8e-07*(feedback_p_w)) ps=max(2*(feedback_p_w)+(5.600000000000001e-07),0) pd=max(2*(feedback_p_w)+(5.600000000000001e-07),0)
FD1Mn (AM AM GND GND) gpdk090_nmos1v w=feedback_n_w l=feedback_n_l m=feedback_n_m as=(2.8e-07*(feedback_n_w)) ad=(2.8e-07*(feedback_n_w)) ps=max(2*(feedback_n_w)+(5.600000000000001e-07),0) pd=max(2*(feedback_n_w)+(5.600000000000001e-07),0)
FD1Mp (AM AM VDD VDD) gpdk090_pmos1v w=feedback_p_w l=feedback_p_l m=feedback_p_m as=(2.8e-07*(feedback_p_w)) ad=(2.8e-07*(feedback_p_w)) ps=max(2*(feedback_p_w)+(5.600000000000001e-07),0) pd=max(2*(feedback_p_w)+(5.600000000000001e-07),0)
OTA2 (AP AM BP BM VT VREF VDD GND) ota_fig2_interpreted M19_l=M19_l M19_m=M19_m M19_w=M19_w M20_l=M20_l M20_m=M20_m M20_w=M20_w M23_l=M23_l M23_m=M23_m M23_w=M23_w M24_l=M24_l M24_m=M24_m M24_w=M24_w M25_l=M25_l M25_m=M25_m M25_w=M25_w M28_l=M28_l M28_m=M28_m M28_w=M28_w bias_n_l=bias_n_l bias_n_m=bias_n_m bias_n_w=bias_n_w bias_p_l=bias_p_l bias_p_m=bias_p_m bias_p_w=bias_p_w cm_fb_n_l=cm_fb_n_l cm_fb_n_m=cm_fb_n_m cm_fb_n_w=cm_fb_n_w cm_fb_p_l=cm_fb_p_l cm_fb_p_m=cm_fb_p_m cm_fb_p_w=cm_fb_p_w cm_node_n_l=cm_node_n_l cm_node_n_m=cm_node_n_m cm_node_n_w=cm_node_n_w cm_node_p_l=cm_node_p_l cm_node_p_m=cm_node_p_m cm_node_p_w=cm_node_p_w cm_out_n_l=cm_out_n_l cm_out_n_m=cm_out_n_m cm_out_n_w=cm_out_n_w cm_out_p_l=cm_out_p_l cm_out_p_m=cm_out_p_m cm_out_p_w=cm_out_p_w cross_n_l=cross_n_l cross_n_m=cross_n_m cross_n_w=cross_n_w cross_p_l=cross_p_l cross_p_m=cross_p_m cross_p_w=cross_p_w input_n_l=input_n_l input_n_m=input_n_m input_n_w=input_n_w input_p_l=input_p_l input_p_m=input_p_m input_p_w=input_p_w load_n_l=load_n_l load_n_m=load_n_m load_n_w=load_n_w load_p_l=load_p_l load_p_m=load_p_m load_p_w=load_p_w
C2 (BP BM) capacitor c=cap_b_F
FD2Pn (BP BP GND GND) gpdk090_nmos1v w=feedback_n_w l=feedback_n_l m=feedback_n_m as=(2.8e-07*(feedback_n_w)) ad=(2.8e-07*(feedback_n_w)) ps=max(2*(feedback_n_w)+(5.600000000000001e-07),0) pd=max(2*(feedback_n_w)+(5.600000000000001e-07),0)
FD2Pp (BP BP VDD VDD) gpdk090_pmos1v w=feedback_p_w l=feedback_p_l m=feedback_p_m as=(2.8e-07*(feedback_p_w)) ad=(2.8e-07*(feedback_p_w)) ps=max(2*(feedback_p_w)+(5.600000000000001e-07),0) pd=max(2*(feedback_p_w)+(5.600000000000001e-07),0)
FD2Mn (BM BM GND GND) gpdk090_nmos1v w=feedback_n_w l=feedback_n_l m=feedback_n_m as=(2.8e-07*(feedback_n_w)) ad=(2.8e-07*(feedback_n_w)) ps=max(2*(feedback_n_w)+(5.600000000000001e-07),0) pd=max(2*(feedback_n_w)+(5.600000000000001e-07),0)
FD2Mp (BM BM VDD VDD) gpdk090_pmos1v w=feedback_p_w l=feedback_p_l m=feedback_p_m as=(2.8e-07*(feedback_p_w)) ad=(2.8e-07*(feedback_p_w)) ps=max(2*(feedback_p_w)+(5.600000000000001e-07),0) pd=max(2*(feedback_p_w)+(5.600000000000001e-07),0)
OTA3 (BP BM DP DM VT VREF VDD GND) ota_fig2_interpreted M19_l=M19_l M19_m=M19_m M19_w=M19_w M20_l=M20_l M20_m=M20_m M20_w=M20_w M23_l=M23_l M23_m=M23_m M23_w=M23_w M24_l=M24_l M24_m=M24_m M24_w=M24_w M25_l=M25_l M25_m=M25_m M25_w=M25_w M28_l=M28_l M28_m=M28_m M28_w=M28_w bias_n_l=bias_n_l bias_n_m=bias_n_m bias_n_w=bias_n_w bias_p_l=bias_p_l bias_p_m=bias_p_m bias_p_w=bias_p_w cm_fb_n_l=cm_fb_n_l cm_fb_n_m=cm_fb_n_m cm_fb_n_w=cm_fb_n_w cm_fb_p_l=cm_fb_p_l cm_fb_p_m=cm_fb_p_m cm_fb_p_w=cm_fb_p_w cm_node_n_l=cm_node_n_l cm_node_n_m=cm_node_n_m cm_node_n_w=cm_node_n_w cm_node_p_l=cm_node_p_l cm_node_p_m=cm_node_p_m cm_node_p_w=cm_node_p_w cm_out_n_l=cm_out_n_l cm_out_n_m=cm_out_n_m cm_out_n_w=cm_out_n_w cm_out_p_l=cm_out_p_l cm_out_p_m=cm_out_p_m cm_out_p_w=cm_out_p_w cross_n_l=cross_n_l cross_n_m=cross_n_m cross_n_w=cross_n_w cross_p_l=cross_p_l cross_p_m=cross_p_m cross_p_w=cross_p_w input_n_l=input_n_l input_n_m=input_n_m input_n_w=input_n_w input_p_l=input_p_l input_p_m=input_p_m input_p_w=input_p_w load_n_l=load_n_l load_n_m=load_n_m load_n_w=load_n_w load_p_l=load_p_l load_p_m=load_p_m load_p_w=load_p_w
C3 (DP DM) capacitor c=cap_d_F
FD3Pn (DP DP GND GND) gpdk090_nmos1v w=feedback_n_w l=feedback_n_l m=feedback_n_m as=(2.8e-07*(feedback_n_w)) ad=(2.8e-07*(feedback_n_w)) ps=max(2*(feedback_n_w)+(5.600000000000001e-07),0) pd=max(2*(feedback_n_w)+(5.600000000000001e-07),0)
FD3Pp (DP DP VDD VDD) gpdk090_pmos1v w=feedback_p_w l=feedback_p_l m=feedback_p_m as=(2.8e-07*(feedback_p_w)) ad=(2.8e-07*(feedback_p_w)) ps=max(2*(feedback_p_w)+(5.600000000000001e-07),0) pd=max(2*(feedback_p_w)+(5.600000000000001e-07),0)
FD3Mn (DM DM GND GND) gpdk090_nmos1v w=feedback_n_w l=feedback_n_l m=feedback_n_m as=(2.8e-07*(feedback_n_w)) ad=(2.8e-07*(feedback_n_w)) ps=max(2*(feedback_n_w)+(5.600000000000001e-07),0) pd=max(2*(feedback_n_w)+(5.600000000000001e-07),0)
FD3Mp (DM DM VDD VDD) gpdk090_pmos1v w=feedback_p_w l=feedback_p_l m=feedback_p_m as=(2.8e-07*(feedback_p_w)) ad=(2.8e-07*(feedback_p_w)) ps=max(2*(feedback_p_w)+(5.600000000000001e-07),0) pd=max(2*(feedback_p_w)+(5.600000000000001e-07),0)
OTA4 (DP DM VOP VOM VT VREF VDD GND) ota_fig2_interpreted M19_l=M19_l M19_m=M19_m M19_w=M19_w M20_l=M20_l M20_m=M20_m M20_w=M20_w M23_l=M23_l M23_m=M23_m M23_w=M23_w M24_l=M24_l M24_m=M24_m M24_w=M24_w M25_l=M25_l M25_m=M25_m M25_w=M25_w M28_l=M28_l M28_m=M28_m M28_w=M28_w bias_n_l=bias_n_l bias_n_m=bias_n_m bias_n_w=bias_n_w bias_p_l=bias_p_l bias_p_m=bias_p_m bias_p_w=bias_p_w cm_fb_n_l=cm_fb_n_l cm_fb_n_m=cm_fb_n_m cm_fb_n_w=cm_fb_n_w cm_fb_p_l=cm_fb_p_l cm_fb_p_m=cm_fb_p_m cm_fb_p_w=cm_fb_p_w cm_node_n_l=cm_node_n_l cm_node_n_m=cm_node_n_m cm_node_n_w=cm_node_n_w cm_node_p_l=cm_node_p_l cm_node_p_m=cm_node_p_m cm_node_p_w=cm_node_p_w cm_out_n_l=cm_out_n_l cm_out_n_m=cm_out_n_m cm_out_n_w=cm_out_n_w cm_out_p_l=cm_out_p_l cm_out_p_m=cm_out_p_m cm_out_p_w=cm_out_p_w cross_n_l=cross_n_l cross_n_m=cross_n_m cross_n_w=cross_n_w cross_p_l=cross_p_l cross_p_m=cross_p_m cross_p_w=cross_p_w input_n_l=input_n_l input_n_m=input_n_m input_n_w=input_n_w input_p_l=input_p_l input_p_m=input_p_m input_p_w=input_p_w load_n_l=load_n_l load_n_m=load_n_m load_n_w=load_n_w load_p_l=load_p_l load_p_m=load_p_m load_p_w=load_p_w
C4 (VOP VOM) capacitor c=cap_d_F
FD4Pn (VOP VOP GND GND) gpdk090_nmos1v w=feedback_n_w l=feedback_n_l m=feedback_n_m as=(2.8e-07*(feedback_n_w)) ad=(2.8e-07*(feedback_n_w)) ps=max(2*(feedback_n_w)+(5.600000000000001e-07),0) pd=max(2*(feedback_n_w)+(5.600000000000001e-07),0)
FD4Pp (VOP VOP VDD VDD) gpdk090_pmos1v w=feedback_p_w l=feedback_p_l m=feedback_p_m as=(2.8e-07*(feedback_p_w)) ad=(2.8e-07*(feedback_p_w)) ps=max(2*(feedback_p_w)+(5.600000000000001e-07),0) pd=max(2*(feedback_p_w)+(5.600000000000001e-07),0)
FD4Mn (VOM VOM GND GND) gpdk090_nmos1v w=feedback_n_w l=feedback_n_l m=feedback_n_m as=(2.8e-07*(feedback_n_w)) ad=(2.8e-07*(feedback_n_w)) ps=max(2*(feedback_n_w)+(5.600000000000001e-07),0) pd=max(2*(feedback_n_w)+(5.600000000000001e-07),0)
FD4Mp (VOM VOM VDD VDD) gpdk090_pmos1v w=feedback_p_w l=feedback_p_l m=feedback_p_m as=(2.8e-07*(feedback_p_w)) ad=(2.8e-07*(feedback_p_w)) ps=max(2*(feedback_p_w)+(5.600000000000001e-07),0) pd=max(2*(feedback_p_w)+(5.600000000000001e-07),0)
ends gmc_filter
