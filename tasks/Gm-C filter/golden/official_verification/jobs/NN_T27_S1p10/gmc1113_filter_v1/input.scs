// analogiq 0.1.0 testbench - generated, do not edit
// task gmc_reconstructed_131126_task_001  topology gmc_reconstructed_131126
// recipe gmc1113_filter_v1 v2  condition NN_T27_S1p10 (models NN, 27 C, supply 1.1 V)
// request gmc131126_final_export_verify  candidate c9f6f3379b10cea4
// execution profile verify
simulator lang=spectre
global 0
include "<PDK_ROOT>/gpdk090_v4.6/models/spectre/gpdk090.scs" section=NN
include "dut.scs"

parameters vsup=1.1
// Sizing variables set in the testbench (external-bias values).
parameters vt_bias_V=0.5647580330549347
// Supplies (charged to the DUT power metrics).
VSUP (vdd 0) vsource dc=vsup
// External bias (topology external_bias; reported separately as bias power).
VB_VT (b_VT 0) vsource dc=vt_bias_V
VB_GND (b_GND 0) vsource dc=0.0

VINP (iin 0) vsource dc=0.55 mag=0.5
VINM (inn 0) vsource dc=0.55 mag=-0.5
VREF_SRC (vocm 0) vsource dc=0.55

XDUT (iin inn out outn b_VT vocm vdd b_GND) gmc_filter M19_l=4.139611362942147e-07 M19_m=1.0 M19_w=1.8948106084351113e-06 M20_l=2.697555715275229e-07 M20_m=1.0 M20_w=1.4532706843959067e-06 M23_l=4.7458098123342276e-07 M23_m=1.0 M23_w=2.5646499510126416e-06 M24_l=2.22979261268972e-07 M24_m=1.0 M24_w=2.4142877712775313e-06 M25_l=1.8376225872228054e-07 M25_m=1.0 M25_w=7.145921500956735e-07 M28_l=2.511109326302167e-07 M28_m=1.0 M28_w=3.130736243000742e-06 bias_n_l=2.1967325249632536e-07 bias_n_m=1.0 bias_n_w=6.245442150019207e-07 bias_p_l=2.379293521829501e-07 bias_p_m=1.0 bias_p_w=2.922769224210927e-06 cap_b_F=7.884111169815835e-13 cap_d_F=3.2331646491198457e-12 cm_fb_n_l=2.88066950542238e-07 cm_fb_n_m=1.0 cm_fb_n_w=3.445955075140213e-07 cm_fb_p_l=1.9370711174580699e-07 cm_fb_p_m=1.0 cm_fb_p_w=1.19871740118854e-06 cm_node_n_l=4.783452882664011e-07 cm_node_n_m=1.0 cm_node_n_w=1.4197553124291605e-06 cm_node_p_l=3.556196510507261e-07 cm_node_p_m=1.0 cm_node_p_w=8.748789928694398e-07 cm_out_n_l=2.1179831998512523e-07 cm_out_n_m=1.0 cm_out_n_w=8.801419180712912e-07 cm_out_p_l=1.1757870980803943e-07 cm_out_p_m=1.0 cm_out_p_w=2.460619766730277e-06 cross_n_l=2.1971700680460613e-07 cross_n_m=1.0 cross_n_w=6.097387050451806e-07 cross_p_l=1.2761518665623804e-07 cross_p_m=1.0 cross_p_w=5.76537527379325e-07 feedback_n_l=1.0012820146194029e-07 feedback_n_m=1.0 feedback_n_w=6.834583309357679e-07 feedback_p_l=1e-07 feedback_p_m=1.0 feedback_p_w=1.031433708291801e-06 input_n_l=1e-07 input_n_m=1.0 input_n_w=6.91011125473508e-07 input_p_l=1e-07 input_p_m=1.0 input_p_w=1.616373198494229e-06 load_n_l=1.0581221839827198e-07 load_n_m=1.0 load_n_w=3.312031907215333e-07 load_p_l=1.6428751788715384e-07 load_p_m=1.0 load_p_w=5.266863858166174e-07
op_info info what=oppoint where=rawfile

opts options temp=27.0 tnom=27 reltol=1e-05 save=selected
save VB_GND:p VB_VT:p VSUP:p iin inn out outn vdd vocm

gmcopts options reltol=1e-6 vabstol=1e-9 iabstol=1e-14
dcOp dc
ac ac start=1 stop=100G dec=500
noise (out outn) noise start=1 stop=1G dec=500 iprobe=VINP save=selected
