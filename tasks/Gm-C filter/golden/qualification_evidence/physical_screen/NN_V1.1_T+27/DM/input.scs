simulator lang=spectre
simulator lang=spectre
global 0
include "<PDK_ROOT>/gpdk090_v4.6/models/spectre/gpdk090.scs" section=NN
// Fig2 literal 32 devices; duplicate red labels suffixed R. Right input label connects M3/M4 drains. Table1 sizes. Ambiguous crossings treated without junction unless terminating/dot.
subckt ota_fig2_literal VIP VIM VOP VOM VT VREF VDD GND
M1 (VOM VIP VDD VDD) gpdk090_pmos1v w=1.61637319849e-06 l=0.1u m=1 as=4.52584495578e-13 ad=4.52584495578e-13 ps=3.79274639699e-06 pd=3.79274639699e-06
M2 (VOM VIP GND GND) gpdk090_nmos1v w=6.91011125474e-07 l=1e-07 m=1 as=1.93483115133e-13 ad=1.93483115133e-13 ps=1.94202225095e-06 pd=1.94202225095e-06
M3 (VIM VOP VDD VDD) gpdk090_pmos1v w=1.61637319849e-06 l=0.1u m=1 as=4.52584495578e-13 ad=4.52584495578e-13 ps=3.79274639699e-06 pd=3.79274639699e-06
M4 (VIM VOP GND GND) gpdk090_nmos1v w=6.91011125474e-07 l=1e-07 m=1 as=1.93483115133e-13 ad=1.93483115133e-13 ps=1.94202225095e-06 pd=1.94202225095e-06
M5 (VOP VOM GND GND) gpdk090_nmos1v w=6.09738705045e-07 l=2.19717006805e-07 m=1 as=1.70726837413e-13 ad=1.70726837413e-13 ps=1.77947741009e-06 pd=1.77947741009e-06
M6 (VOP VOM VDD VDD) gpdk090_pmos1v w=5.76537527379e-07 l=1.27615186656e-07 m=1 as=1.61430507666e-13 ad=1.61430507666e-13 ps=1.71307505476e-06 pd=1.71307505476e-06
M7 (VOP BN GND GND) gpdk090_nmos1v w=3.31203190722e-07 l=1.05812218398e-07 m=1 as=9.2736893402e-14 ad=9.2736893402e-14 ps=1.22240638144e-06 pd=1.22240638144e-06
M8 (VOP BP VDD VDD) gpdk090_pmos1v w=5.26686385817e-07 l=1.64287517887e-07 m=1 as=1.47472188029e-13 ad=1.47472188029e-13 ps=1.61337277163e-06 pd=1.61337277163e-06
M9 (VOM VOP GND GND) gpdk090_nmos1v w=6.09738705045e-07 l=2.19717006805e-07 m=1 as=1.70726837413e-13 ad=1.70726837413e-13 ps=1.77947741009e-06 pd=1.77947741009e-06
M10 (VOM VOP VDD VDD) gpdk090_pmos1v w=5.76537527379e-07 l=1.27615186656e-07 m=1 as=1.61430507666e-13 ad=1.61430507666e-13 ps=1.71307505476e-06 pd=1.71307505476e-06
M11 (VOM BN GND GND) gpdk090_nmos1v w=3.31203190722e-07 l=1.05812218398e-07 m=1 as=9.2736893402e-14 ad=9.2736893402e-14 ps=1.22240638144e-06 pd=1.22240638144e-06
M12 (VOM BP VDD VDD) gpdk090_pmos1v w=5.26686385817e-07 l=1.64287517887e-07 m=1 as=1.47472188029e-13 ad=1.47472188029e-13 ps=1.61337277163e-06 pd=1.61337277163e-06
M13 (VOM N GND GND) gpdk090_nmos1v w=8.80141918071e-07 l=2.11798319985e-07 m=1 as=2.4643973706e-13 ad=2.4643973706e-13 ps=2.32028383614e-06 pd=2.32028383614e-06
M14 (VOM N VDD VDD) gpdk090_pmos1v w=2.46061976673e-06 l=1.17578709808e-07 m=1 as=6.88973534684e-13 ad=6.88973534684e-13 ps=5.48123953346e-06 pd=5.48123953346e-06
M15 (VOP N GND GND) gpdk090_nmos1v w=8.80141918071e-07 l=2.11798319985e-07 m=1 as=2.4643973706e-13 ad=2.4643973706e-13 ps=2.32028383614e-06 pd=2.32028383614e-06
M16 (VOP N VDD VDD) gpdk090_pmos1v w=2.46061976673e-06 l=1.17578709808e-07 m=1 as=6.88973534684e-13 ad=6.88973534684e-13 ps=5.48123953346e-06 pd=5.48123953346e-06
M17 (N N GND GND) gpdk090_nmos1v w=1.41975531243e-06 l=4.78345288266e-07 m=1 as=3.9753148748e-13 ad=3.9753148748e-13 ps=3.39951062486e-06 pd=3.39951062486e-06
M18 (N N VDD VDD) gpdk090_pmos1v w=8.74878992869e-07 l=3.55619651051e-07 m=1 as=2.44966118003e-13 ad=2.44966118003e-13 ps=2.30975798574e-06 pd=2.30975798574e-06
M19 (N VIP GND GND) gpdk090_nmos1v w=1.89481060844e-06 l=4.13961136294e-07 m=1 as=5.30546970361e-13 ad=5.30546970361e-13 ps=4.34962121687e-06 pd=4.34962121687e-06
M20 (N VIM VDD VDD) gpdk090_pmos1v w=1.4532706844e-06 l=2.69755571528e-07 m=1 as=4.0691579163e-13 ad=4.0691579163e-13 ps=3.46654136879e-06 pd=3.46654136879e-06
M21 (FB VOM GND GND) gpdk090_nmos1v w=3.44595507514e-07 l=2.88066950542e-07 m=1 as=9.64867421039e-14 ad=9.64867421039e-14 ps=1.24919101503e-06 pd=1.24919101503e-06
M22 (FB VOP VDD VDD) gpdk090_pmos1v w=1.19871740119e-06 l=1.93707111746e-07 m=1 as=3.35640872333e-13 ad=3.35640872333e-13 ps=2.95743480238e-06 pd=2.95743480238e-06
M23 (N VREF GND GND) gpdk090_nmos1v w=2.56464995101e-06 l=4.74580981233e-07 m=1 as=7.18101986283e-13 ad=7.18101986283e-13 ps=5.68929990203e-06 pd=5.68929990203e-06
M24 (N FB VDD VDD) gpdk090_pmos1v w=2.41428777128e-06 l=2.22979261269e-07 m=1 as=6.76000575957e-13 ad=6.76000575957e-13 ps=5.38857554256e-06 pd=5.38857554256e-06
M25 (BP VT GND GND) gpdk090_nmos1v w=7.14592150096e-07 l=1.83762258722e-07 m=1 as=2.00085802027e-13 ad=2.00085802027e-13 ps=1.98918430019e-06 pd=1.98918430019e-06
M26 (BN BN GND GND) gpdk090_nmos1v w=6.24544215002e-07 l=2.19673252496e-07 m=1 as=1.74872380201e-13 ad=1.74872380201e-13 ps=1.80908843e-06 pd=1.80908843e-06
M27 (BP BP VDD VDD) gpdk090_pmos1v w=2.92276922421e-06 l=2.37929352183e-07 m=1 as=8.18375382779e-13 ad=8.18375382779e-13 ps=6.40553844842e-06 pd=6.40553844842e-06
M28 (BN BP VDD VDD) gpdk090_pmos1v w=3.130736243e-06 l=2.5111093263e-07 m=1 as=8.7660614804e-13 ad=8.7660614804e-13 ps=6.821472486e-06 pd=6.821472486e-06
M25R (N N VDD VDD) gpdk090_pmos1v w=8.74878992869e-07 l=3.55619651051e-07 m=1 as=2.44966118003e-13 ad=2.44966118003e-13 ps=2.30975798574e-06 pd=2.30975798574e-06
M26R (N N GND GND) gpdk090_nmos1v w=1.41975531243e-06 l=4.78345288266e-07 m=1 as=3.9753148748e-13 ad=3.9753148748e-13 ps=3.39951062486e-06 pd=3.39951062486e-06
M27R (N N VDD VDD) gpdk090_pmos1v w=8.74878992869e-07 l=3.55619651051e-07 m=1 as=2.44966118003e-13 ad=2.44966118003e-13 ps=2.30975798574e-06 pd=2.30975798574e-06
M28R (N N GND GND) gpdk090_nmos1v w=1.41975531243e-06 l=4.78345288266e-07 m=1 as=3.9753148748e-13 ad=3.9753148748e-13 ps=3.39951062486e-06 pd=3.39951062486e-06
ends ota_fig2_literal
// Fig2 interpretation: correct right inverter semantic Vi-/Vo+ labels by swapping M3/M4 gate/drain nets. All 32 MOS Table1 sizes unchanged. Assumption-dependent.
subckt ota_fig2_interpreted VIP VIM VOP VOM VT VREF VDD GND
M1 (VOM VIP VDD VDD) gpdk090_pmos1v w=1.61637319849e-06 l=0.1u m=1 as=4.52584495578e-13 ad=4.52584495578e-13 ps=3.79274639699e-06 pd=3.79274639699e-06
M2 (VOM VIP GND GND) gpdk090_nmos1v w=6.91011125474e-07 l=1e-07 m=1 as=1.93483115133e-13 ad=1.93483115133e-13 ps=1.94202225095e-06 pd=1.94202225095e-06
M3 (VOP VIM VDD VDD) gpdk090_pmos1v w=1.61637319849e-06 l=0.1u m=1 as=4.52584495578e-13 ad=4.52584495578e-13 ps=3.79274639699e-06 pd=3.79274639699e-06
M4 (VOP VIM GND GND) gpdk090_nmos1v w=6.91011125474e-07 l=1e-07 m=1 as=1.93483115133e-13 ad=1.93483115133e-13 ps=1.94202225095e-06 pd=1.94202225095e-06
M5 (VOP VOM GND GND) gpdk090_nmos1v w=6.09738705045e-07 l=2.19717006805e-07 m=1 as=1.70726837413e-13 ad=1.70726837413e-13 ps=1.77947741009e-06 pd=1.77947741009e-06
M6 (VOP VOM VDD VDD) gpdk090_pmos1v w=5.76537527379e-07 l=1.27615186656e-07 m=1 as=1.61430507666e-13 ad=1.61430507666e-13 ps=1.71307505476e-06 pd=1.71307505476e-06
M7 (VOP BN GND GND) gpdk090_nmos1v w=3.31203190722e-07 l=1.05812218398e-07 m=1 as=9.2736893402e-14 ad=9.2736893402e-14 ps=1.22240638144e-06 pd=1.22240638144e-06
M8 (VOP BP VDD VDD) gpdk090_pmos1v w=5.26686385817e-07 l=1.64287517887e-07 m=1 as=1.47472188029e-13 ad=1.47472188029e-13 ps=1.61337277163e-06 pd=1.61337277163e-06
M9 (VOM VOP GND GND) gpdk090_nmos1v w=6.09738705045e-07 l=2.19717006805e-07 m=1 as=1.70726837413e-13 ad=1.70726837413e-13 ps=1.77947741009e-06 pd=1.77947741009e-06
M10 (VOM VOP VDD VDD) gpdk090_pmos1v w=5.76537527379e-07 l=1.27615186656e-07 m=1 as=1.61430507666e-13 ad=1.61430507666e-13 ps=1.71307505476e-06 pd=1.71307505476e-06
M11 (VOM BN GND GND) gpdk090_nmos1v w=3.31203190722e-07 l=1.05812218398e-07 m=1 as=9.2736893402e-14 ad=9.2736893402e-14 ps=1.22240638144e-06 pd=1.22240638144e-06
M12 (VOM BP VDD VDD) gpdk090_pmos1v w=5.26686385817e-07 l=1.64287517887e-07 m=1 as=1.47472188029e-13 ad=1.47472188029e-13 ps=1.61337277163e-06 pd=1.61337277163e-06
M13 (VOM N GND GND) gpdk090_nmos1v w=8.80141918071e-07 l=2.11798319985e-07 m=1 as=2.4643973706e-13 ad=2.4643973706e-13 ps=2.32028383614e-06 pd=2.32028383614e-06
M14 (VOM N VDD VDD) gpdk090_pmos1v w=2.46061976673e-06 l=1.17578709808e-07 m=1 as=6.88973534684e-13 ad=6.88973534684e-13 ps=5.48123953346e-06 pd=5.48123953346e-06
M15 (VOP N GND GND) gpdk090_nmos1v w=8.80141918071e-07 l=2.11798319985e-07 m=1 as=2.4643973706e-13 ad=2.4643973706e-13 ps=2.32028383614e-06 pd=2.32028383614e-06
M16 (VOP N VDD VDD) gpdk090_pmos1v w=2.46061976673e-06 l=1.17578709808e-07 m=1 as=6.88973534684e-13 ad=6.88973534684e-13 ps=5.48123953346e-06 pd=5.48123953346e-06
M17 (N N GND GND) gpdk090_nmos1v w=1.41975531243e-06 l=4.78345288266e-07 m=1 as=3.9753148748e-13 ad=3.9753148748e-13 ps=3.39951062486e-06 pd=3.39951062486e-06
M18 (N N VDD VDD) gpdk090_pmos1v w=8.74878992869e-07 l=3.55619651051e-07 m=1 as=2.44966118003e-13 ad=2.44966118003e-13 ps=2.30975798574e-06 pd=2.30975798574e-06
M19 (N VIP GND GND) gpdk090_nmos1v w=1.89481060844e-06 l=4.13961136294e-07 m=1 as=5.30546970361e-13 ad=5.30546970361e-13 ps=4.34962121687e-06 pd=4.34962121687e-06
M20 (N VIM VDD VDD) gpdk090_pmos1v w=1.4532706844e-06 l=2.69755571528e-07 m=1 as=4.0691579163e-13 ad=4.0691579163e-13 ps=3.46654136879e-06 pd=3.46654136879e-06
M21 (FB VOM GND GND) gpdk090_nmos1v w=3.44595507514e-07 l=2.88066950542e-07 m=1 as=9.64867421039e-14 ad=9.64867421039e-14 ps=1.24919101503e-06 pd=1.24919101503e-06
M22 (FB VOP VDD VDD) gpdk090_pmos1v w=1.19871740119e-06 l=1.93707111746e-07 m=1 as=3.35640872333e-13 ad=3.35640872333e-13 ps=2.95743480238e-06 pd=2.95743480238e-06
M23 (N VREF GND GND) gpdk090_nmos1v w=2.56464995101e-06 l=4.74580981233e-07 m=1 as=7.18101986283e-13 ad=7.18101986283e-13 ps=5.68929990203e-06 pd=5.68929990203e-06
M24 (N FB VDD VDD) gpdk090_pmos1v w=2.41428777128e-06 l=2.22979261269e-07 m=1 as=6.76000575957e-13 ad=6.76000575957e-13 ps=5.38857554256e-06 pd=5.38857554256e-06
M25 (BP VT GND GND) gpdk090_nmos1v w=7.14592150096e-07 l=1.83762258722e-07 m=1 as=2.00085802027e-13 ad=2.00085802027e-13 ps=1.98918430019e-06 pd=1.98918430019e-06
M26 (BN BN GND GND) gpdk090_nmos1v w=6.24544215002e-07 l=2.19673252496e-07 m=1 as=1.74872380201e-13 ad=1.74872380201e-13 ps=1.80908843e-06 pd=1.80908843e-06
M27 (BP BP VDD VDD) gpdk090_pmos1v w=2.92276922421e-06 l=2.37929352183e-07 m=1 as=8.18375382779e-13 ad=8.18375382779e-13 ps=6.40553844842e-06 pd=6.40553844842e-06
M28 (BN BP VDD VDD) gpdk090_pmos1v w=3.130736243e-06 l=2.5111093263e-07 m=1 as=8.7660614804e-13 ad=8.7660614804e-13 ps=6.821472486e-06 pd=6.821472486e-06
M25R (N N VDD VDD) gpdk090_pmos1v w=8.74878992869e-07 l=3.55619651051e-07 m=1 as=2.44966118003e-13 ad=2.44966118003e-13 ps=2.30975798574e-06 pd=2.30975798574e-06
M26R (N N GND GND) gpdk090_nmos1v w=1.41975531243e-06 l=4.78345288266e-07 m=1 as=3.9753148748e-13 ad=3.9753148748e-13 ps=3.39951062486e-06 pd=3.39951062486e-06
M27R (N N VDD VDD) gpdk090_pmos1v w=8.74878992869e-07 l=3.55619651051e-07 m=1 as=2.44966118003e-13 ad=2.44966118003e-13 ps=2.30975798574e-06 pd=2.30975798574e-06
M28R (N N GND GND) gpdk090_nmos1v w=1.41975531243e-06 l=4.78345288266e-07 m=1 as=3.9753148748e-13 ad=3.9753148748e-13 ps=3.39951062486e-06 pd=3.39951062486e-06
ends ota_fig2_interpreted
// NON-PAPER adapter: four 1k resistors average main and side differential inputs. Fig3 side-terminal function absent in Fig2; disclosed executable hypothesis, not paper-exact.
// Experimental reconstruction: four distinct differential capacitor states.
// Same32MOS OTA core; four physical diode feedback MOS per stage; no summing resistors.
subckt filter_four_state_candidate VIP VIM VOP VOM VT VREF VDD GND
OTA1 (VIP VIM AP AM VT VREF VDD GND) ota_fig2_interpreted
C1 (AP AM) capacitor c=7.88411116982e-13
FD1Pn (AP AP GND GND) gpdk090_nmos1v w=6.83458330936e-07 l=1.00128201462e-07 m=1 as=1.91368332662e-13 ad=1.91368332662e-13 ps=1.92691666187e-06 pd=1.92691666187e-06
FD1Pp (AP AP VDD VDD) gpdk090_pmos1v w=1.03143370829e-06 l=1e-07 m=1 as=2.88801438322e-13 ad=2.88801438322e-13 ps=2.62286741658e-06 pd=2.62286741658e-06
FD1Mn (AM AM GND GND) gpdk090_nmos1v w=6.83458330936e-07 l=1.00128201462e-07 m=1 as=1.91368332662e-13 ad=1.91368332662e-13 ps=1.92691666187e-06 pd=1.92691666187e-06
FD1Mp (AM AM VDD VDD) gpdk090_pmos1v w=1.03143370829e-06 l=1e-07 m=1 as=2.88801438322e-13 ad=2.88801438322e-13 ps=2.62286741658e-06 pd=2.62286741658e-06
OTA2 (AP AM BP BM VT VREF VDD GND) ota_fig2_interpreted
C2 (BP BM) capacitor c=7.88411116982e-13
FD2Pn (BP BP GND GND) gpdk090_nmos1v w=6.83458330936e-07 l=1.00128201462e-07 m=1 as=1.91368332662e-13 ad=1.91368332662e-13 ps=1.92691666187e-06 pd=1.92691666187e-06
FD2Pp (BP BP VDD VDD) gpdk090_pmos1v w=1.03143370829e-06 l=1e-07 m=1 as=2.88801438322e-13 ad=2.88801438322e-13 ps=2.62286741658e-06 pd=2.62286741658e-06
FD2Mn (BM BM GND GND) gpdk090_nmos1v w=6.83458330936e-07 l=1.00128201462e-07 m=1 as=1.91368332662e-13 ad=1.91368332662e-13 ps=1.92691666187e-06 pd=1.92691666187e-06
FD2Mp (BM BM VDD VDD) gpdk090_pmos1v w=1.03143370829e-06 l=1e-07 m=1 as=2.88801438322e-13 ad=2.88801438322e-13 ps=2.62286741658e-06 pd=2.62286741658e-06
OTA3 (BP BM DP DM VT VREF VDD GND) ota_fig2_interpreted
C3 (DP DM) capacitor c=3.23316464912e-12
FD3Pn (DP DP GND GND) gpdk090_nmos1v w=6.83458330936e-07 l=1.00128201462e-07 m=1 as=1.91368332662e-13 ad=1.91368332662e-13 ps=1.92691666187e-06 pd=1.92691666187e-06
FD3Pp (DP DP VDD VDD) gpdk090_pmos1v w=1.03143370829e-06 l=1e-07 m=1 as=2.88801438322e-13 ad=2.88801438322e-13 ps=2.62286741658e-06 pd=2.62286741658e-06
FD3Mn (DM DM GND GND) gpdk090_nmos1v w=6.83458330936e-07 l=1.00128201462e-07 m=1 as=1.91368332662e-13 ad=1.91368332662e-13 ps=1.92691666187e-06 pd=1.92691666187e-06
FD3Mp (DM DM VDD VDD) gpdk090_pmos1v w=1.03143370829e-06 l=1e-07 m=1 as=2.88801438322e-13 ad=2.88801438322e-13 ps=2.62286741658e-06 pd=2.62286741658e-06
OTA4 (DP DM VOP VOM VT VREF VDD GND) ota_fig2_interpreted
C4 (VOP VOM) capacitor c=3.23316464912e-12
FD4Pn (VOP VOP GND GND) gpdk090_nmos1v w=6.83458330936e-07 l=1.00128201462e-07 m=1 as=1.91368332662e-13 ad=1.91368332662e-13 ps=1.92691666187e-06 pd=1.92691666187e-06
FD4Pp (VOP VOP VDD VDD) gpdk090_pmos1v w=1.03143370829e-06 l=1e-07 m=1 as=2.88801438322e-13 ad=2.88801438322e-13 ps=2.62286741658e-06 pd=2.62286741658e-06
FD4Mn (VOM VOM GND GND) gpdk090_nmos1v w=6.83458330936e-07 l=1.00128201462e-07 m=1 as=1.91368332662e-13 ad=1.91368332662e-13 ps=1.92691666187e-06 pd=1.92691666187e-06
FD4Mp (VOM VOM VDD VDD) gpdk090_pmos1v w=1.03143370829e-06 l=1e-07 m=1 as=2.88801438322e-13 ad=2.88801438322e-13 ps=2.62286741658e-06 pd=2.62286741658e-06
ends filter_four_state_candidate
DUT (VIP VIM VOP VOM VT VREF VDD 0) filter_four_state_candidate
VDD_SRC (VDD 0) vsource dc=1.1
VT_SRC (VT 0) vsource dc=0.564758033055
VREF_SRC (VREF 0) vsource dc=0.55
VINP (VIP 0) vsource dc=0.55 mag=0.5 type=pulse val0=0.55 val1=0.55005 delay=100n rise=10p fall=10p width=1u period=2u
VINM (VIM 0) vsource dc=0.55 mag=-0.5 type=pulse val0=0.55 val1=0.54995 delay=100n rise=10p fall=10p width=1u period=2u
simulatorOptions options reltol=1e-6 vabstol=1e-9 iabstol=1e-14 temp=27 tnom=27
saveOptions options save=selected currents=selected
save VOP VOM VIP VIM DUT.AP DUT.AM DUT.BP DUT.BM DUT.DP DUT.DM
save DUT:oppoint
dcOp dc
dcOpInfo info what=oppoint where=rawfile
save DUT.OTA1.BN DUT.OTA1.BP DUT.OTA1.FB DUT.OTA1.N DUT.OTA2.BN DUT.OTA2.BP DUT.OTA2.FB DUT.OTA2.N DUT.OTA3.BN DUT.OTA3.BP DUT.OTA3.FB DUT.OTA3.N DUT.OTA4.BN DUT.OTA4.BP DUT.OTA4.FB DUT.OTA4.N
ac ac start=1 stop=1.01 lin=2
step tran stop=500n maxstep=5p strobeperiod=5p errpreset=conservative
