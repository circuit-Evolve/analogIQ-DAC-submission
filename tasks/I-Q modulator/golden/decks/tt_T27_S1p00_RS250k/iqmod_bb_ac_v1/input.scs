// analogiq 0.1.0 testbench - generated, do not edit
// task tinywhisper24_iqmod_task_001  topology tinywhisper24_iqmod
// recipe iqmod_bb_ac_v1 v2  condition tt_T27_S1p00_RS250k (models tt, 27 C, supply 1.5 V)
// request golden_tinywhisper24_iqmod_task_001  candidate fade3bb1883e8ead
// execution profile search_full
simulator lang=spectre
global 0
include "<PDK_ROOT>/sky130_cds/spectre/libs.tech/combined/sky130.lib.spice" section=tt
include "dut.scs"

parameters vcm=0.75 adp=0.5 adn=-0.5 vsup=1.5 vneg=0.0
// Supplies (charged to the DUT power metrics).
VSUP (vdd 0) vsource dc=vsup
VNEG (vss 0) vsource dc=vneg
// External bias (topology external_bias; reported separately as bias power).
VB_di_analog_en (vdd b_di_analog_en) vsource dc=0.0

// Baseband drive (iqmod_top_tb_ac: the same source on the I and Q analog inputs); differential run:
// +-0.5 V (1 V differential), common-mode run: 1 V on both inputs.
VCMI (vcmi 0) vsource dc=vcm
VDIP (spI vcmi) vsource dc=0 mag=adp
VDIN (snI vcmi) vsource dc=0 mag=adn
RSIP (spI inp) resistor r=250000.0
RSIN (snI inn) resistor r=250000.0
VDQP (spQ vcmi) vsource dc=0 mag=adp
VDQN (snQ vcmi) vsource dc=0 mag=adn
RSQP (spQ qinp) resistor r=250000.0
RSQN (snQ qinn) resistor r=250000.0
// all four LO pins static high (mixer switches on); SPDT select; DAC-side inputs not used.
VLOP (lop 0) vsource dc=vsup
VLON (lon 0) vsource dc=vsup
VLQP (loqp 0) vsource dc=vsup
VLQN (loqn 0) vsource dc=vsup
VSPI (spdti 0) vsource dc=vsup
VSPQ (spdtq 0) vsource dc=vsup
VDSIP (dsip 0) vsource dc=0
VDSIN (dsin 0) vsource dc=0
VDSQP (dsqp 0) vsource dc=0
VDSQN (dsqn 0) vsource dc=0
CL_out (out 0) capacitor c=1e-11
CL_outn (outn 0) capacitor c=1e-11
CL_qout (qout 0) capacitor c=1e-11
CL_qoutn (qoutn 0) capacitor c=1e-11

XDUT (dsip spdti dsin dsqn spdtq dsqp qinp qinn lop lon out inp inn loqp loqn outn qout qoutn vdd vss b_di_analog_en) tinywhisper24_iqmod_dut C1=5.758749920445077e-13 C2=3.3814515175191856e-13 C3=1.7793776929890496e-13 L_MIXDM_N=1.803120361734324e-07 L_MIXDM_P=1.7396988915119065e-07 L_MIXTG_N=1.7855661847508312e-07 L_MIXTG_P=1.5886318316133925e-07 L_OTA10_N=8.637717837082378e-07 L_OTA10_P=1.0215602677623376e-06 L_OTA20_N=4.416009325214188e-07 L_OTA20_P=4.3614226523483623e-07 L_OTA6_N=1.4888767341034955e-06 L_OTA6_P=2.2904829789316446e-06 NF_MIXDM_N=32.0 NF_MIXDM_P=10.0 NF_MIXTG_N=82.0 NF_MIXTG_P=74.0 NF_OTA10_N=3.0 NF_OTA10_P=4.0 NF_OTA20_N=77.0 NF_OTA20_P=42.0 NF_OTA6_N=3.0 NF_OTA6_P=6.0 R1=83303.34702016425 R2=89728.10117507937 R3=135353.50554026093 R4=180447.66430906954 W_MIXDM_N=5.372873380453248e-06 W_MIXDM_P=1.2271116372792597e-05 W_MIXTG_N=1.7464203213075386e-05 W_MIXTG_P=4.3262577632298716e-05 W_OTA10_N=8.196025430622402e-07 W_OTA10_P=3.0923972156351057e-06 W_OTA20_N=3.435135756690563e-06 W_OTA20_P=1.3818476268210842e-05 W_OTA6_N=5.721992465392439e-07 W_OTA6_P=7.011773904756253e-06
op_info info what=oppoint where=rawfile

opts options temp=27.0 tnom=27 reltol=0.0001 save=selected
save VB_di_analog_en:p VDIN:p VDIP:p VNEG:p VSUP:p dsin dsip dsqn dsqp inn inp lon lop loqn loqp out outn qinn qinp qout qoutn spdti spdtq vdd vss

ac1 ac start=1.0 stop=200000000.0 dec=50
altcm1 alter param=adp value=1
altcm2 alter param=adn value=1
ac2 ac start=1.0 stop=200000000.0 dec=50
altdm1 alter param=adp value=0.5
altdm2 alter param=adn value=-0.5
