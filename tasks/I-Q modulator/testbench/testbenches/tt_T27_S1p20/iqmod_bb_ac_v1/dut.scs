// Generated by analogiq from dut_benchmark.scs (sha256 3724a25a7582d0d1).
// Connectivity and device models are unchanged except for the listed transformations:
//   - iqmod_mfb_lpf_ota_core_inv_NF6.M1: mult bound to M_OTA6_N; Spectre multiplicity m follows it
//   - iqmod_mfb_lpf_ota_core_inv_NF6.M1: junction geometry ad/as/pd/ps rewritten in terms of the bound width (area = Lj*W, perimeter = 2*W + c; Lj and c from the netlist)
//   - iqmod_mfb_lpf_ota_core_inv_NF6.M2: mult bound to M_OTA6_P; Spectre multiplicity m follows it
//   - iqmod_mfb_lpf_ota_core_inv_NF6.M2: junction geometry ad/as/pd/ps rewritten in terms of the bound width (area = Lj*W, perimeter = 2*W + c; Lj and c from the netlist)
//   - iqmod_mfb_lpf_ota_core_inv_NF10.M1: mult bound to M_OTA10_N; Spectre multiplicity m follows it
//   - iqmod_mfb_lpf_ota_core_inv_NF10.M1: junction geometry ad/as/pd/ps rewritten in terms of the bound width (area = Lj*W, perimeter = 2*W + c; Lj and c from the netlist)
//   - iqmod_mfb_lpf_ota_core_inv_NF10.M2: mult bound to M_OTA10_P; Spectre multiplicity m follows it
//   - iqmod_mfb_lpf_ota_core_inv_NF10.M2: junction geometry ad/as/pd/ps rewritten in terms of the bound width (area = Lj*W, perimeter = 2*W + c; Lj and c from the netlist)
//   - iqmod_mfb_lpf_ota_core_inv_NF20.M1: mult bound to M_OTA20_N; Spectre multiplicity m follows it
//   - iqmod_mfb_lpf_ota_core_inv_NF20.M1: junction geometry ad/as/pd/ps rewritten in terms of the bound width (area = Lj*W, perimeter = 2*W + c; Lj and c from the netlist)
//   - iqmod_mfb_lpf_ota_core_inv_NF20.M2: mult bound to M_OTA20_P; Spectre multiplicity m follows it
//   - iqmod_mfb_lpf_ota_core_inv_NF20.M2: junction geometry ad/as/pd/ps rewritten in terms of the bound width (area = Lj*W, perimeter = 2*W + c; Lj and c from the netlist)
//   - iqmod_mixer_tg.M1: mult bound to M_MIXTG_N; Spectre multiplicity m follows it
//   - iqmod_mixer_tg.M1: junction geometry ad/as/pd/ps rewritten in terms of the bound width (area = Lj*W, perimeter = 2*W + c; Lj and c from the netlist)
//   - iqmod_mixer_tg.M2: mult bound to M_MIXTG_P; Spectre multiplicity m follows it
//   - iqmod_mixer_tg.M2: junction geometry ad/as/pd/ps rewritten in terms of the bound width (area = Lj*W, perimeter = 2*W + c; Lj and c from the netlist)
//   - iqmod_mixer_tg.Mdummy2: mult bound to M_MIXDM_P; Spectre multiplicity m follows it
//   - iqmod_mixer_tg.Mdummy2: junction geometry ad/as/pd/ps rewritten in terms of the bound width (area = Lj*W, perimeter = 2*W + c; Lj and c from the netlist)
//   - iqmod_mixer_tg.Mdummy1: mult bound to M_MIXDM_N; Spectre multiplicity m follows it
//   - iqmod_mixer_tg.Mdummy1: junction geometry ad/as/pd/ps rewritten in terms of the bound width (area = Lj*W, perimeter = 2*W + c; Lj and c from the netlist)
//   - sizing variables bound inside local subckts are subckt parameters passed from the DUT instance(s): iqmod_mfb_lpf_ota_core_inv_NF6: ['L_OTA6_N', 'L_OTA6_P', 'M_OTA6_N', 'M_OTA6_P', 'NF_OTA6_N', 'NF_OTA6_P', 'W_OTA6_N', 'W_OTA6_P'], iqmod_mfb_lpf_ota_core_inv_NF10: ['L_OTA10_N', 'L_OTA10_P', 'M_OTA10_N', 'M_OTA10_P', 'NF_OTA10_N', 'NF_OTA10_P', 'W_OTA10_N', 'W_OTA10_P'], iqmod_mfb_lpf_ota_core_inv_NF20: ['L_OTA20_N', 'L_OTA20_P', 'M_OTA20_N', 'M_OTA20_P', 'NF_OTA20_N', 'NF_OTA20_P', 'W_OTA20_N', 'W_OTA20_P'], iqmod_mfb_lpf_R4: ['R4'], iqmod_mfb_lpf_R3: ['R3'], iqmod_mfb_lpf_R2: ['R2'], iqmod_mfb_lpf_R1: ['R1'], iqmod_mfb_lpf_ota_core_hybrid_bm: ['L_OTA10_N', 'L_OTA10_P', 'L_OTA20_N', 'L_OTA20_P', 'L_OTA6_N', 'L_OTA6_P', 'M_OTA10_N', 'M_OTA10_P', 'M_OTA20_N', 'M_OTA20_P', 'M_OTA6_N', 'M_OTA6_P', 'NF_OTA10_N', 'NF_OTA10_P', 'NF_OTA20_N', 'NF_OTA20_P', 'NF_OTA6_N', 'NF_OTA6_P', 'W_OTA10_N', 'W_OTA10_P', 'W_OTA20_N', 'W_OTA20_P', 'W_OTA6_N', 'W_OTA6_P'], iqmod_mixer_tg: ['L_MIXDM_N', 'L_MIXDM_P', 'L_MIXTG_N', 'L_MIXTG_P', 'M_MIXDM_N', 'M_MIXDM_P', 'M_MIXTG_N', 'M_MIXTG_P', 'NF_MIXDM_N', 'NF_MIXDM_P', 'NF_MIXTG_N', 'NF_MIXTG_P', 'W_MIXDM_N', 'W_MIXDM_P', 'W_MIXTG_N', 'W_MIXTG_P'], iqmod_mfb_lpf: ['C1', 'C2', 'C3', 'L_OTA10_N', 'L_OTA10_P', 'L_OTA20_N', 'L_OTA20_P', 'L_OTA6_N', 'L_OTA6_P', 'M_OTA10_N', 'M_OTA10_P', 'M_OTA20_N', 'M_OTA20_P', 'M_OTA6_N', 'M_OTA6_P', 'NF_OTA10_N', 'NF_OTA10_P', 'NF_OTA20_N', 'NF_OTA20_P', 'NF_OTA6_N', 'NF_OTA6_P', 'R1', 'R2', 'R3', 'R4', 'W_OTA10_N', 'W_OTA10_P', 'W_OTA20_N', 'W_OTA20_P', 'W_OTA6_N', 'W_OTA6_P'], iqmod_mixer: ['L_MIXDM_N', 'L_MIXDM_P', 'L_MIXTG_N', 'L_MIXTG_P', 'M_MIXDM_N', 'M_MIXDM_P', 'M_MIXTG_N', 'M_MIXTG_P', 'NF_MIXDM_N', 'NF_MIXDM_P', 'NF_MIXTG_N', 'NF_MIXTG_P', 'W_MIXDM_N', 'W_MIXDM_P', 'W_MIXTG_N', 'W_MIXTG_P'], iqmod_top_half: ['C1', 'C2', 'C3', 'L_MIXDM_N', 'L_MIXDM_P', 'L_MIXTG_N', 'L_MIXTG_P', 'L_OTA10_N', 'L_OTA10_P', 'L_OTA20_N', 'L_OTA20_P', 'L_OTA6_N', 'L_OTA6_P', 'M_MIXDM_N', 'M_MIXDM_P', 'M_MIXTG_N', 'M_MIXTG_P', 'M_OTA10_N', 'M_OTA10_P', 'M_OTA20_N', 'M_OTA20_P', 'M_OTA6_N', 'M_OTA6_P', 'NF_MIXDM_N', 'NF_MIXDM_P', 'NF_MIXTG_N', 'NF_MIXTG_P', 'NF_OTA10_N', 'NF_OTA10_P', 'NF_OTA20_N', 'NF_OTA20_P', 'NF_OTA6_N', 'NF_OTA6_P', 'R1', 'R2', 'R3', 'R4', 'W_MIXDM_N', 'W_MIXDM_P', 'W_MIXTG_N', 'W_MIXTG_P', 'W_OTA10_N', 'W_OTA10_P', 'W_OTA20_N', 'W_OTA20_P', 'W_OTA6_N', 'W_OTA6_P'], iqmod_top: ['C1', 'C2', 'C3', 'L_MIXDM_N', 'L_MIXDM_P', 'L_MIXTG_N', 'L_MIXTG_P', 'L_OTA10_N', 'L_OTA10_P', 'L_OTA20_N', 'L_OTA20_P', 'L_OTA6_N', 'L_OTA6_P', 'M_MIXDM_N', 'M_MIXDM_P', 'M_MIXTG_N', 'M_MIXTG_P', 'M_OTA10_N', 'M_OTA10_P', 'M_OTA20_N', 'M_OTA20_P', 'M_OTA6_N', 'M_OTA6_P', 'NF_MIXDM_N', 'NF_MIXDM_P', 'NF_MIXTG_N', 'NF_MIXTG_P', 'NF_OTA10_N', 'NF_OTA10_P', 'NF_OTA20_N', 'NF_OTA20_P', 'NF_OTA6_N', 'NF_OTA6_P', 'R1', 'R2', 'R3', 'R4', 'W_MIXDM_N', 'W_MIXDM_P', 'W_MIXTG_N', 'W_MIXTG_P', 'W_OTA10_N', 'W_OTA10_P', 'W_OTA20_N', 'W_OTA20_P', 'W_OTA6_N', 'W_OTA6_P']
//   - netlist parameters bound to sizing variables: W_MIXDM_N <- W_MIXDM_N, W_MIXDM_P <- W_MIXDM_P, W_MIXTG_N <- W_MIXTG_N, W_MIXTG_P <- W_MIXTG_P, W_OTA10_N <- W_OTA10_N, W_OTA10_P <- W_OTA10_P, W_OTA20_N <- W_OTA20_N, W_OTA20_P <- W_OTA20_P, W_OTA6_N <- W_OTA6_N, W_OTA6_P <- W_OTA6_P
subckt iqmod_mfb_lpf_ota_core_spdt_switch_tg (VDD di_tg_ctrl VSS v_b v_a di_tg_ctrl_n)
  M2 (v_a di_tg_ctrl_n v_b VDD) sky130_fd_pr__pfet_01v8 w=41.5384615385 l=0.15 nf=6 mult=1 ad=6.02308 as=8.03077 pd=43.2785 ps=57.7046 sa=0 sb=0 sd=0 m=1
  M1 (v_a di_tg_ctrl v_b VSS) sky130_fd_pr__nfet_01v8 w=6.92307692308 l=0.15 nf=6 mult=1 ad=1.00385 as=1.33846 pd=8.66308 ps=11.5508 sa=0 sb=0 sd=0 m=1
ends iqmod_mfb_lpf_ota_core_spdt_switch_tg
subckt iqmod_mfb_lpf_ota_core_spdt_switch_inv (VDD vin vout VSS)
  M1 (vout vin VSS VSS) sky130_fd_pr__nfet_01v8 w=2.30769230769 l=0.15 nf=2 mult=1 ad=0.334615 as=0.669231 pd=2.88769 ps=5.77538 sa=0 sb=0 sd=0 m=1
  M2 (vout vin VDD VDD) sky130_fd_pr__pfet_01v8 w=13.8461538462 l=0.15 nf=2 mult=1 ad=2.00769 as=4.01538 pd=14.4262 ps=28.8523 sa=0 sb=0 sd=0 m=1
  Mdummy1 (VSS VSS VSS VSS) sky130_fd_pr__nfet_01v8 w=2.30769230769 l=0.15 nf=2 mult=1 ad=0.334615 as=0.669231 pd=2.88769 ps=5.77538 sa=0 sb=0 sd=0 m=1
  Mdummy2 (VDD VDD VDD VDD) sky130_fd_pr__pfet_01v8 w=13.8461538462 l=0.15 nf=2 mult=1 ad=2.00769 as=4.01538 pd=14.4262 ps=28.8523 sa=0 sb=0 sd=0 m=1
ends iqmod_mfb_lpf_ota_core_spdt_switch_inv
subckt iqmod_mfb_lpf_ota_core_tg (VDD di_tg_ctrl VSS v_b v_a di_tg_ctrl_n)
  M2 (v_a di_tg_ctrl_n v_b VDD) sky130_fd_pr__pfet_01v8 w=41.5384615385 l=0.15 nf=6 mult=1 ad=6.02308 as=8.03077 pd=43.2785 ps=57.7046 sa=0 sb=0 sd=0 m=1
  M1 (v_a di_tg_ctrl v_b VSS) sky130_fd_pr__nfet_01v8 w=6.92307692308 l=0.15 nf=6 mult=1 ad=1.00385 as=1.33846 pd=8.66308 ps=11.5508 sa=0 sb=0 sd=0 m=1
ends iqmod_mfb_lpf_ota_core_tg
subckt iqmod_mfb_lpf_ota_core_spdt_switch (do_spdt_ctrl_n VDD di_spdt_ctrl VSS v_c v_b v_a)
  x1 (VDD di_spdt_ctrl do_spdt_ctrl_n VSS) iqmod_mfb_lpf_ota_core_spdt_switch_inv
  x2 (VDD do_spdt_ctrl_n spdt_ctrl_buf VSS) iqmod_mfb_lpf_ota_core_spdt_switch_inv
  x3 (VDD spdt_ctrl_buf VSS v_c v_a do_spdt_ctrl_n) iqmod_mfb_lpf_ota_core_spdt_switch_tg
  x4 (VDD do_spdt_ctrl_n VSS v_c v_b spdt_ctrl_buf) iqmod_mfb_lpf_ota_core_spdt_switch_tg
ends iqmod_mfb_lpf_ota_core_spdt_switch
subckt iqmod_mfb_lpf_ota_core_inv_NF6 (VDD vin vout VSS)
  parameters L_OTA6_N=1e-06 L_OTA6_P=1e-06 M_OTA6_N=1.0 M_OTA6_P=1.0 NF_OTA6_N=1.0 NF_OTA6_P=1.0 W_OTA6_N=1e-06 W_OTA6_P=1e-06
  Mdummy1 (VSS VSS VSS VSS) sky130_fd_pr__nfet_01v8 w=2 l=1 nf=2 mult=1 ad=0.29 as=0.58 pd=2.58 ps=5.16 sa=0 sb=0 sd=0 m=1
  Mdummy2 (VDD VDD VDD VDD) sky130_fd_pr__pfet_01v8 w=12 l=1 nf=2 mult=1 ad=1.74 as=3.48 pd=12.58 ps=25.16 sa=0 sb=0 sd=0 m=1
  M1 (vout vin VSS VSS) sky130_fd_pr__nfet_01v8 w=((W_OTA6_N*NF_OTA6_N)/1e-06) l=(L_OTA6_N/1e-06) nf=NF_OTA6_N mult=M_OTA6_N ad=(0.145*(((W_OTA6_N*NF_OTA6_N)/1e-06))) as=(0.19333333333333333*(((W_OTA6_N*NF_OTA6_N)/1e-06))) pd=max(2*(((W_OTA6_N*NF_OTA6_N)/1e-06))+(-4.26),0) ps=max(2*(((W_OTA6_N*NF_OTA6_N)/1e-06))+(-1.6799999999999997),0) sa=0 sb=0 sd=0 m=M_OTA6_N
  M2 (vout vin VDD VDD) sky130_fd_pr__pfet_01v8 w=((W_OTA6_P*NF_OTA6_P)/1e-06) l=(L_OTA6_P/1e-06) nf=NF_OTA6_P mult=M_OTA6_P ad=(0.145*(((W_OTA6_P*NF_OTA6_P)/1e-06))) as=(0.19333333333333333*(((W_OTA6_P*NF_OTA6_P)/1e-06))) pd=max(2*(((W_OTA6_P*NF_OTA6_P)/1e-06))+(-34.26),0) ps=max(2*(((W_OTA6_P*NF_OTA6_P)/1e-06))+(-21.68),0) sa=0 sb=0 sd=0 m=M_OTA6_P
ends iqmod_mfb_lpf_ota_core_inv_NF6
subckt iqmod_mfb_lpf_ota_core_inv_NF10 (VDD vin vout VSS)
  parameters L_OTA10_N=1e-06 L_OTA10_P=1e-06 M_OTA10_N=1.0 M_OTA10_P=1.0 NF_OTA10_N=1.0 NF_OTA10_P=1.0 W_OTA10_N=1e-06 W_OTA10_P=1e-06
  M1 (vout vin VSS VSS) sky130_fd_pr__nfet_01v8 w=((W_OTA10_N*NF_OTA10_N)/1e-06) l=(L_OTA10_N/1e-06) nf=NF_OTA10_N mult=M_OTA10_N ad=(0.145*(((W_OTA10_N*NF_OTA10_N)/1e-06))) as=(0.174*(((W_OTA10_N*NF_OTA10_N)/1e-06))) pd=max(2*(((W_OTA10_N*NF_OTA10_N)/1e-06))+(-7.1),0) ps=max(2*(((W_OTA10_N*NF_OTA10_N)/1e-06))+(-4.52),0) sa=0 sb=0 sd=0 m=M_OTA10_N
  M2 (vout vin VDD VDD) sky130_fd_pr__pfet_01v8 w=((W_OTA10_P*NF_OTA10_P)/1e-06) l=(L_OTA10_P/1e-06) nf=NF_OTA10_P mult=M_OTA10_P ad=(0.145*(((W_OTA10_P*NF_OTA10_P)/1e-06))) as=(0.174*(((W_OTA10_P*NF_OTA10_P)/1e-06))) pd=max(2*(((W_OTA10_P*NF_OTA10_P)/1e-06))+(-57.1),0) ps=max(2*(((W_OTA10_P*NF_OTA10_P)/1e-06))+(-44.519999999999996),0) sa=0 sb=0 sd=0 m=M_OTA10_P
  Mdummy1 (VSS VSS VSS VSS) sky130_fd_pr__nfet_01v8 w=2 l=1 nf=2 mult=1 ad=0.29 as=0.58 pd=2.58 ps=5.16 sa=0 sb=0 sd=0 m=1
  Mdummy2 (VDD VDD VDD VDD) sky130_fd_pr__pfet_01v8 w=12 l=1 nf=2 mult=1 ad=1.74 as=3.48 pd=12.58 ps=25.16 sa=0 sb=0 sd=0 m=1
ends iqmod_mfb_lpf_ota_core_inv_NF10
subckt iqmod_mfb_lpf_ota_core_inv_NF20 (VDD vin vout VSS)
  parameters L_OTA20_N=1e-06 L_OTA20_P=1e-06 M_OTA20_N=1.0 M_OTA20_P=1.0 NF_OTA20_N=1.0 NF_OTA20_P=1.0 W_OTA20_N=1e-06 W_OTA20_P=1e-06
  Mdummy1 (VSS VSS VSS VSS) sky130_fd_pr__nfet_01v8 w=2 l=1 nf=2 mult=1 ad=0.29 as=0.58 pd=2.58 ps=5.16 sa=0 sb=0 sd=0 m=1
  Mdummy2 (VDD VDD VDD VDD) sky130_fd_pr__pfet_01v8 w=12 l=1 nf=2 mult=1 ad=1.74 as=3.48 pd=12.58 ps=25.16 sa=0 sb=0 sd=0 m=1
  M1 (vout vin VSS VSS) sky130_fd_pr__nfet_01v8 w=((W_OTA20_N*NF_OTA20_N)/1e-06) l=(L_OTA20_N/1e-06) nf=NF_OTA20_N mult=M_OTA20_N ad=(0.145*(((W_OTA20_N*NF_OTA20_N)/1e-06))) as=(0.1595*(((W_OTA20_N*NF_OTA20_N)/1e-06))) pd=max(2*(((W_OTA20_N*NF_OTA20_N)/1e-06))+(-14.2),0) ps=max(2*(((W_OTA20_N*NF_OTA20_N)/1e-06))+(-11.620000000000001),0) sa=0 sb=0 sd=0 m=M_OTA20_N
  M2 (vout vin VDD VDD) sky130_fd_pr__pfet_01v8 w=((W_OTA20_P*NF_OTA20_P)/1e-06) l=(L_OTA20_P/1e-06) nf=NF_OTA20_P mult=M_OTA20_P ad=(0.145*(((W_OTA20_P*NF_OTA20_P)/1e-06))) as=(0.1595*(((W_OTA20_P*NF_OTA20_P)/1e-06))) pd=max(2*(((W_OTA20_P*NF_OTA20_P)/1e-06))+(-114.2),0) ps=max(2*(((W_OTA20_P*NF_OTA20_P)/1e-06))+(-101.62),0) sa=0 sb=0 sd=0 m=M_OTA20_P
ends iqmod_mfb_lpf_ota_core_inv_NF20
subckt iqmod_mixer_se2diff_inv_NF54 (VDD vin vout VSS)
  M1 (vout vin VSS VSS) sky130_fd_pr__nfet_01v8 w=62.3076923077 l=0.15 nf=54 mult=1 ad=9.03462 as=9.36923 pd=77.9677 ps=80.8554 sa=0 sb=0 sd=0 m=1
  M2 (vout vin VDD VDD) sky130_fd_pr__pfet_01v8 w=186.923076923 l=0.15 nf=54 mult=1 ad=27.1038 as=28.1077 pd=202.583 ps=210.086 sa=0 sb=0 sd=0 m=1
  Mdummy1 (VSS VSS VSS VSS) sky130_fd_pr__nfet_01v8 w=2.30769230769 l=0.15 nf=2 mult=1 ad=0.334615 as=0.669231 pd=2.88769 ps=5.77538 sa=0 sb=0 sd=0 m=1
  Mdummy2 (VDD VDD VDD VDD) sky130_fd_pr__pfet_01v8 w=6.92307692308 l=0.15 nf=2 mult=1 ad=1.00385 as=2.00769 pd=7.50308 ps=15.0062 sa=0 sb=0 sd=0 m=1
ends iqmod_mixer_se2diff_inv_NF54
subckt iqmod_mixer_se2diff_inv_NF6 (VDD vin vout VSS)
  M1 (vout vin VSS VSS) sky130_fd_pr__nfet_01v8 w=6.92307692308 l=0.15 nf=6 mult=1 ad=1.00385 as=1.33846 pd=8.66308 ps=11.5508 sa=0 sb=0 sd=0 m=1
  M2 (vout vin VDD VDD) sky130_fd_pr__pfet_01v8 w=20.7692307692 l=0.15 nf=6 mult=1 ad=3.01154 as=4.01538 pd=22.5092 ps=30.0123 sa=0 sb=0 sd=0 m=1
  Mdummy1 (VSS VSS VSS VSS) sky130_fd_pr__nfet_01v8 w=2.30769230769 l=0.15 nf=2 mult=1 ad=0.334615 as=0.669231 pd=2.88769 ps=5.77538 sa=0 sb=0 sd=0 m=1
  Mdummy2 (VDD VDD VDD VDD) sky130_fd_pr__pfet_01v8 w=6.92307692308 l=0.15 nf=2 mult=1 ad=1.00385 as=2.00769 pd=7.50308 ps=15.0062 sa=0 sb=0 sd=0 m=1
ends iqmod_mixer_se2diff_inv_NF6
subckt iqmod_mixer_se2diff_inv_NF2 (VDD vin vout VSS)
  M1 (vout vin VSS VSS) sky130_fd_pr__nfet_01v8 w=2.30769230769 l=0.15 nf=2 mult=1 ad=0.334615 as=0.669231 pd=2.88769 ps=5.77538 sa=0 sb=0 sd=0 m=1
  M2 (vout vin VDD VDD) sky130_fd_pr__pfet_01v8 w=6.92307692308 l=0.15 nf=2 mult=1 ad=1.00385 as=2.00769 pd=7.50308 ps=15.0062 sa=0 sb=0 sd=0 m=1
  Mdummy1 (VSS VSS VSS VSS) sky130_fd_pr__nfet_01v8 w=2.30769230769 l=0.15 nf=2 mult=1 ad=0.334615 as=0.669231 pd=2.88769 ps=5.77538 sa=0 sb=0 sd=0 m=1
  Mdummy2 (VDD VDD VDD VDD) sky130_fd_pr__pfet_01v8 w=6.92307692308 l=0.15 nf=2 mult=1 ad=1.00385 as=2.00769 pd=7.50308 ps=15.0062 sa=0 sb=0 sd=0 m=1
ends iqmod_mixer_se2diff_inv_NF2
subckt iqmod_mixer_se2diff_inv_NF18 (VDD vin vout VSS)
  M1 (vout vin VSS VSS) sky130_fd_pr__nfet_01v8 w=20.7692307692 l=0.15 nf=18 mult=1 ad=3.01154 as=3.34615 pd=25.9892 ps=28.8769 sa=0 sb=0 sd=0 m=1
  M2 (vout vin VDD VDD) sky130_fd_pr__pfet_01v8 w=62.3076923077 l=0.15 nf=18 mult=1 ad=9.03462 as=10.0385 pd=67.5277 ps=75.0308 sa=0 sb=0 sd=0 m=1
  Mdummy1 (VSS VSS VSS VSS) sky130_fd_pr__nfet_01v8 w=2.30769230769 l=0.15 nf=2 mult=1 ad=0.334615 as=0.669231 pd=2.88769 ps=5.77538 sa=0 sb=0 sd=0 m=1
  Mdummy2 (VDD VDD VDD VDD) sky130_fd_pr__pfet_01v8 w=6.92307692308 l=0.15 nf=2 mult=1 ad=1.00385 as=2.00769 pd=7.50308 ps=15.0062 sa=0 sb=0 sd=0 m=1
ends iqmod_mixer_se2diff_inv_NF18
subckt iqmod_mixer_se2diff_tg_NF6 (VDD di_tg_ctrl VSS v_b v_a di_tg_ctrl_n)
  M2 (v_a di_tg_ctrl_n v_b VDD) sky130_fd_pr__pfet_01v8 w=20.7692307692 l=0.15 nf=6 mult=1 ad=3.01154 as=4.01538 pd=22.5092 ps=30.0123 sa=0 sb=0 sd=0 m=1
  M1 (v_a di_tg_ctrl v_b VSS) sky130_fd_pr__nfet_01v8 w=6.92307692308 l=0.15 nf=6 mult=1 ad=1.00385 as=1.33846 pd=8.66308 ps=11.5508 sa=0 sb=0 sd=0 m=1
ends iqmod_mixer_se2diff_tg_NF6
subckt iqmod_spdt_switch_tg (VDD di_tg_ctrl VSS v_b v_a di_tg_ctrl_n)
  M2 (v_a di_tg_ctrl_n v_b VDD) sky130_fd_pr__pfet_01v8 w=41.5384615385 l=0.15 nf=6 mult=1 ad=6.02308 as=8.03077 pd=43.2785 ps=57.7046 sa=0 sb=0 sd=0 m=1
  M1 (v_a di_tg_ctrl v_b VSS) sky130_fd_pr__nfet_01v8 w=6.92307692308 l=0.15 nf=6 mult=1 ad=1.00385 as=1.33846 pd=8.66308 ps=11.5508 sa=0 sb=0 sd=0 m=1
ends iqmod_spdt_switch_tg
subckt iqmod_spdt_switch_inv (VDD vin vout VSS)
  M1 (vout vin VSS VSS) sky130_fd_pr__nfet_01v8 w=2.30769230769 l=0.15 nf=2 mult=1 ad=0.334615 as=0.669231 pd=2.88769 ps=5.77538 sa=0 sb=0 sd=0 m=1
  M2 (vout vin VDD VDD) sky130_fd_pr__pfet_01v8 w=13.8461538462 l=0.15 nf=2 mult=1 ad=2.00769 as=4.01538 pd=14.4262 ps=28.8523 sa=0 sb=0 sd=0 m=1
  Mdummy1 (VSS VSS VSS VSS) sky130_fd_pr__nfet_01v8 w=2.30769230769 l=0.15 nf=2 mult=1 ad=0.334615 as=0.669231 pd=2.88769 ps=5.77538 sa=0 sb=0 sd=0 m=1
  Mdummy2 (VDD VDD VDD VDD) sky130_fd_pr__pfet_01v8 w=13.8461538462 l=0.15 nf=2 mult=1 ad=2.00769 as=4.01538 pd=14.4262 ps=28.8523 sa=0 sb=0 sd=0 m=1
ends iqmod_spdt_switch_inv
subckt iqmod_mfb_lpf_R4 (v_b v_a VSS)
  parameters R4=10000.0
  R1 (v_a net1) resistor r=R4
  R2 (net1 net2) resistor r=R4
  R3 (net2 v_b) resistor r=R4
  Rdummy1 (VSS VSS) resistor r=R4
  Rdummy2 (VSS VSS) resistor r=R4
ends iqmod_mfb_lpf_R4
subckt iqmod_mfb_lpf_R3 (v_b v_a VSS)
  parameters R3=10000.0
  R1 (v_a net1) resistor r=R3
  R2 (net1 net2) resistor r=R3
  R3 (net2 v_b) resistor r=R3
  Rdummy1 (VSS VSS) resistor r=R3
  Rdummy2 (VSS VSS) resistor r=R3
ends iqmod_mfb_lpf_R3
subckt iqmod_mfb_lpf_R2 (v_b v_a VSS)
  parameters R2=10000.0
  R1 (v_a net1) resistor r=R2
  R2 (net1 net2) resistor r=R2
  R3 (net2 v_b) resistor r=R2
  Rdummy1 (VSS VSS) resistor r=R2
  Rdummy2 (VSS VSS) resistor r=R2
ends iqmod_mfb_lpf_R2
subckt iqmod_mfb_lpf_R1 (v_b v_a VSS)
  parameters R1=10000.0
  R1 (v_a net1) resistor r=R1
  R2 (net1 net2) resistor r=R1
  R3 (net2 v_b) resistor r=R1
  Rdummy1 (VSS VSS) resistor r=R1
  Rdummy2 (VSS VSS) resistor r=R1
ends iqmod_mfb_lpf_R1
subckt iqmod_mfb_lpf_ota_core_hybrid_bm (voutp voutn vinn vinp VDD VSS di_ota_en)
  parameters L_OTA10_N=1e-06 L_OTA10_P=1e-06 L_OTA20_N=1e-06 L_OTA20_P=1e-06 L_OTA6_N=1e-06 L_OTA6_P=1e-06 M_OTA10_N=1.0 M_OTA10_P=1.0 M_OTA20_N=1.0 M_OTA20_P=1.0 M_OTA6_N=1.0 M_OTA6_P=1.0 NF_OTA10_N=1.0 NF_OTA10_P=1.0 NF_OTA20_N=1.0 NF_OTA20_P=1.0 NF_OTA6_N=1.0 NF_OTA6_P=1.0 W_OTA10_N=1e-06 W_OTA10_P=1e-06 W_OTA20_N=1e-06 W_OTA20_P=1e-06 W_OTA6_N=1e-06 W_OTA6_P=1e-06
  x6 (VDD node_CDG voutn VSS) iqmod_mfb_lpf_ota_core_inv_NF20 L_OTA20_N=L_OTA20_N L_OTA20_P=L_OTA20_P M_OTA20_N=M_OTA20_N M_OTA20_P=M_OTA20_P NF_OTA20_N=NF_OTA20_N NF_OTA20_P=NF_OTA20_P W_OTA20_N=W_OTA20_N W_OTA20_P=W_OTA20_P
  x7 (VDD node_CDG voutp VSS) iqmod_mfb_lpf_ota_core_inv_NF20 L_OTA20_N=L_OTA20_N L_OTA20_P=L_OTA20_P M_OTA20_N=M_OTA20_N M_OTA20_P=M_OTA20_P NF_OTA20_N=NF_OTA20_N NF_OTA20_P=NF_OTA20_P W_OTA20_N=W_OTA20_N W_OTA20_P=W_OTA20_P
  x11 (VDD voutn node_EF VSS) iqmod_mfb_lpf_ota_core_inv_NF20 L_OTA20_N=L_OTA20_N L_OTA20_P=L_OTA20_P M_OTA20_N=M_OTA20_N M_OTA20_P=M_OTA20_P NF_OTA20_N=NF_OTA20_N NF_OTA20_P=NF_OTA20_P W_OTA20_N=W_OTA20_N W_OTA20_P=W_OTA20_P
  x12 (VDD voutp node_EF VSS) iqmod_mfb_lpf_ota_core_inv_NF20 L_OTA20_N=L_OTA20_N L_OTA20_P=L_OTA20_P M_OTA20_N=M_OTA20_N M_OTA20_P=M_OTA20_P NF_OTA20_N=NF_OTA20_N NF_OTA20_P=NF_OTA20_P W_OTA20_N=W_OTA20_N W_OTA20_P=W_OTA20_P
  x9 (VDD node_vinp node_BC VSS) iqmod_mfb_lpf_ota_core_inv_NF10 L_OTA10_N=L_OTA10_N L_OTA10_P=L_OTA10_P M_OTA10_N=M_OTA10_N M_OTA10_P=M_OTA10_P NF_OTA10_N=NF_OTA10_N NF_OTA10_P=NF_OTA10_P W_OTA10_N=W_OTA10_N W_OTA10_P=W_OTA10_P
  x10 (VDD node_vinn node_BC VSS) iqmod_mfb_lpf_ota_core_inv_NF10 L_OTA10_N=L_OTA10_N L_OTA10_P=L_OTA10_P M_OTA10_N=M_OTA10_N M_OTA10_P=M_OTA10_P NF_OTA10_N=NF_OTA10_N NF_OTA10_P=NF_OTA10_P W_OTA10_N=W_OTA10_N W_OTA10_P=W_OTA10_P
  x5 (VDD node_EF node_FG VSS) iqmod_mfb_lpf_ota_core_inv_NF6 L_OTA6_N=L_OTA6_N L_OTA6_P=L_OTA6_P M_OTA6_N=M_OTA6_N M_OTA6_P=M_OTA6_P NF_OTA6_N=NF_OTA6_N NF_OTA6_P=NF_OTA6_P W_OTA6_N=W_OTA6_N W_OTA6_P=W_OTA6_P
  x1 (VDD node_BC node_CDG VSS) iqmod_mfb_lpf_ota_core_inv_NF6 L_OTA6_N=L_OTA6_N L_OTA6_P=L_OTA6_P M_OTA6_N=M_OTA6_N M_OTA6_P=M_OTA6_P NF_OTA6_N=NF_OTA6_N NF_OTA6_P=NF_OTA6_P W_OTA6_N=W_OTA6_N W_OTA6_P=W_OTA6_P
  x4 (VDD node_BC node_CDG VSS) iqmod_mfb_lpf_ota_core_inv_NF6 L_OTA6_N=L_OTA6_N L_OTA6_P=L_OTA6_P M_OTA6_N=M_OTA6_N M_OTA6_P=M_OTA6_P NF_OTA6_N=NF_OTA6_N NF_OTA6_P=NF_OTA6_P W_OTA6_N=W_OTA6_N W_OTA6_P=W_OTA6_P
  x13 (VDD node_EF node_FG VSS) iqmod_mfb_lpf_ota_core_inv_NF6 L_OTA6_N=L_OTA6_N L_OTA6_P=L_OTA6_P M_OTA6_N=M_OTA6_N M_OTA6_P=M_OTA6_P NF_OTA6_N=NF_OTA6_N NF_OTA6_P=NF_OTA6_P W_OTA6_N=W_OTA6_N W_OTA6_P=W_OTA6_P
  x8 (VDD node_FG node_CDG VSS) iqmod_mfb_lpf_ota_core_inv_NF6 L_OTA6_N=L_OTA6_N L_OTA6_P=L_OTA6_P M_OTA6_N=M_OTA6_N M_OTA6_P=M_OTA6_P NF_OTA6_N=NF_OTA6_N NF_OTA6_P=NF_OTA6_P W_OTA6_N=W_OTA6_N W_OTA6_P=W_OTA6_P
  x14 (VDD node_FG node_CDG VSS) iqmod_mfb_lpf_ota_core_inv_NF6 L_OTA6_N=L_OTA6_N L_OTA6_P=L_OTA6_P M_OTA6_N=M_OTA6_N M_OTA6_P=M_OTA6_P NF_OTA6_N=NF_OTA6_N NF_OTA6_P=NF_OTA6_P W_OTA6_N=W_OTA6_N W_OTA6_P=W_OTA6_P
  x2 (VDD node_vinp voutn VSS) iqmod_mfb_lpf_ota_core_inv_NF20 L_OTA20_N=L_OTA20_N L_OTA20_P=L_OTA20_P M_OTA20_N=M_OTA20_N M_OTA20_P=M_OTA20_P NF_OTA20_N=NF_OTA20_N NF_OTA20_P=NF_OTA20_P W_OTA20_N=W_OTA20_N W_OTA20_P=W_OTA20_P
  x3 (VDD node_vinn voutp VSS) iqmod_mfb_lpf_ota_core_inv_NF20 L_OTA20_N=L_OTA20_N L_OTA20_P=L_OTA20_P M_OTA20_N=M_OTA20_N M_OTA20_P=M_OTA20_P NF_OTA20_N=NF_OTA20_N NF_OTA20_P=NF_OTA20_P W_OTA20_N=W_OTA20_N W_OTA20_P=W_OTA20_P
  x16 (ota_en_n_1 VDD di_ota_en VSS node_vinp VDD vinp) iqmod_mfb_lpf_ota_core_spdt_switch
  x17 (ota_en_n_2 VDD di_ota_en VSS node_vinn VDD vinn) iqmod_mfb_lpf_ota_core_spdt_switch
  x15 (VDD di_ota_en VSS node_CDG node_BC ota_en_n_1) iqmod_mfb_lpf_ota_core_tg
  x18 (VDD di_ota_en VSS node_FG node_EF ota_en_n_1) iqmod_mfb_lpf_ota_core_tg
  x20 (VDD di_ota_en VSS node_CDG node_BC ota_en_n_2) iqmod_mfb_lpf_ota_core_tg
  x23 (VDD di_ota_en VSS node_FG node_EF ota_en_n_2) iqmod_mfb_lpf_ota_core_tg
ends iqmod_mfb_lpf_ota_core_hybrid_bm
subckt iqmod_mixer_se2diff (VDD vin voutp VSS voutn)
  x3 (VDD VDD VSS net2 vse VSS) iqmod_mixer_se2diff_tg_NF6
  x8 (VDD vscale1n vscale2p VSS) iqmod_mixer_se2diff_inv_NF18
  x5 (VDD vcrossp vcrossn VSS) iqmod_mixer_se2diff_inv_NF2
  x6 (VDD vcrossn vcrossp VSS) iqmod_mixer_se2diff_inv_NF2
  x2 (VDD net1 vcrossp VSS) iqmod_mixer_se2diff_inv_NF6
  x4 (VDD net2 vcrossn VSS) iqmod_mixer_se2diff_inv_NF6
  x7 (VDD vcrossp vscale1n VSS) iqmod_mixer_se2diff_inv_NF6
  x1 (VDD vse net1 VSS) iqmod_mixer_se2diff_inv_NF6
  x9 (VDD vscale2p voutp VSS) iqmod_mixer_se2diff_inv_NF54
  x10 (VDD vcrossn vscale1p VSS) iqmod_mixer_se2diff_inv_NF6
  x11 (VDD vscale1p vscale2n VSS) iqmod_mixer_se2diff_inv_NF18
  x12 (VDD vscale2n voutn VSS) iqmod_mixer_se2diff_inv_NF54
  x13 (VDD vin vse VSS) iqmod_mixer_se2diff_inv_NF2
  x14 (VDD vin vse VSS) iqmod_mixer_se2diff_inv_NF2
ends iqmod_mixer_se2diff
subckt iqmod_mixer_tg (VDD di_tg_ctrl VSS v_b v_a di_tg_ctrl_n)
  parameters L_MIXDM_N=1e-06 L_MIXDM_P=1e-06 L_MIXTG_N=1e-06 L_MIXTG_P=1e-06 M_MIXDM_N=1.0 M_MIXDM_P=1.0 M_MIXTG_N=1.0 M_MIXTG_P=1.0 NF_MIXDM_N=1.0 NF_MIXDM_P=1.0 NF_MIXTG_N=1.0 NF_MIXTG_P=1.0 W_MIXDM_N=1e-06 W_MIXDM_P=1e-06 W_MIXTG_N=1e-06 W_MIXTG_P=1e-06
  M1 (v_a di_tg_ctrl v_b VSS) sky130_fd_pr__nfet_01v8 w=((W_MIXTG_N*NF_MIXTG_N)/1e-06) l=(L_MIXTG_N/1e-06) nf=NF_MIXTG_N mult=M_MIXTG_N ad=(0.14499975308686727*(((W_MIXTG_N*NF_MIXTG_N)/1e-06))) as=(0.15305574074121314*(((W_MIXTG_N*NF_MIXTG_N)/1e-06))) pd=max(2*(((W_MIXTG_N*NF_MIXTG_N)/1e-06))+(-114.17576922999999),0) ps=max(2*(((W_MIXTG_N*NF_MIXTG_N)/1e-06))+(-106.67276923),0) sa=0 sb=0 sd=0 m=M_MIXTG_N
  M2 (v_a di_tg_ctrl_n v_b VDD) sky130_fd_pr__pfet_01v8 w=((W_MIXTG_P*NF_MIXTG_P)/1e-06) l=(L_MIXTG_P/1e-06) nf=NF_MIXTG_P mult=M_MIXTG_P ad=(0.14500002057619138*(((W_MIXTG_P*NF_MIXTG_P)/1e-06))) as=(0.15305547325109178*(((W_MIXTG_P*NF_MIXTG_P)/1e-06))) pd=max(2*(((W_MIXTG_P*NF_MIXTG_P)/1e-06))+(-363.406307692),0) ps=max(2*(((W_MIXTG_P*NF_MIXTG_P)/1e-06))+(-342.057307692),0) sa=0 sb=0 sd=0 m=M_MIXTG_P
  Mdummy2 (v_b di_tg_ctrl v_b VDD) sky130_fd_pr__pfet_01v8 w=((W_MIXDM_P*NF_MIXDM_P)/1e-06) l=(L_MIXDM_P/1e-06) nf=NF_MIXDM_P mult=M_MIXDM_P ad=(0.14499975308647942*(((W_MIXDM_P*NF_MIXDM_P)/1e-06))) as=(0.16111119341570418*(((W_MIXDM_P*NF_MIXDM_P)/1e-06))) pd=max(2*(((W_MIXDM_P*NF_MIXDM_P)/1e-06))+(-181.703153846),0) ps=max(2*(((W_MIXDM_P*NF_MIXDM_P)/1e-06))+(-160.354153846),0) sa=0 sb=0 sd=0 m=M_MIXDM_P
  Mdummy1 (v_b di_tg_ctrl_n v_b VSS) sky130_fd_pr__nfet_01v8 w=((W_MIXDM_N*NF_MIXDM_N)/1e-06) l=(L_MIXDM_N/1e-06) nf=NF_MIXDM_N mult=M_MIXDM_N ad=(0.14500007407405618*(((W_MIXDM_N*NF_MIXDM_N)/1e-06))) as=(0.16111172839504184*(((W_MIXDM_N*NF_MIXDM_N)/1e-06))) pd=max(2*(((W_MIXDM_N*NF_MIXDM_N)/1e-06))+(-57.08768461540001),0) ps=max(2*(((W_MIXDM_N*NF_MIXDM_N)/1e-06))+(-49.584584615400004),0) sa=0 sb=0 sd=0 m=M_MIXDM_N
ends iqmod_mixer_tg
subckt iqmod_spdt_switch (VDD di_spdt_ctrl VSS v_c v_b v_a)
  x1 (VDD di_spdt_ctrl spdt_ctrl_n VSS) iqmod_spdt_switch_inv
  x2 (VDD spdt_ctrl_n spdt_ctrl_buf VSS) iqmod_spdt_switch_inv
  x3 (VDD spdt_ctrl_buf VSS v_c v_a spdt_ctrl_n) iqmod_spdt_switch_tg
  x4 (VDD spdt_ctrl_n VSS v_c v_b spdt_ctrl_buf) iqmod_spdt_switch_tg
ends iqmod_spdt_switch
subckt iqmod_mfb_lpf (voutp vinp voutn vinn VDD VSS di_filter_en)
  parameters C1=1e-12 C2=1e-12 C3=1e-12 L_OTA10_N=1e-06 L_OTA10_P=1e-06 L_OTA20_N=1e-06 L_OTA20_P=1e-06 L_OTA6_N=1e-06 L_OTA6_P=1e-06 M_OTA10_N=1.0 M_OTA10_P=1.0 M_OTA20_N=1.0 M_OTA20_P=1.0 M_OTA6_N=1.0 M_OTA6_P=1.0 NF_OTA10_N=1.0 NF_OTA10_P=1.0 NF_OTA20_N=1.0 NF_OTA20_P=1.0 NF_OTA6_N=1.0 NF_OTA6_P=1.0 R1=10000.0 R2=10000.0 R3=10000.0 R4=10000.0 W_OTA10_N=1e-06 W_OTA10_P=1e-06 W_OTA20_N=1e-06 W_OTA20_P=1e-06 W_OTA6_N=1e-06 W_OTA6_P=1e-06
  x1 (voutp voutn vinn_ota vinp_ota VDD VSS di_filter_en) iqmod_mfb_lpf_ota_core_hybrid_bm L_OTA10_N=L_OTA10_N L_OTA10_P=L_OTA10_P L_OTA20_N=L_OTA20_N L_OTA20_P=L_OTA20_P L_OTA6_N=L_OTA6_N L_OTA6_P=L_OTA6_P M_OTA10_N=M_OTA10_N M_OTA10_P=M_OTA10_P M_OTA20_N=M_OTA20_N M_OTA20_P=M_OTA20_P M_OTA6_N=M_OTA6_N M_OTA6_P=M_OTA6_P NF_OTA10_N=NF_OTA10_N NF_OTA10_P=NF_OTA10_P NF_OTA20_N=NF_OTA20_N NF_OTA20_P=NF_OTA20_P NF_OTA6_N=NF_OTA6_N NF_OTA6_P=NF_OTA6_P W_OTA10_N=W_OTA10_N W_OTA10_P=W_OTA10_P W_OTA20_N=W_OTA20_N W_OTA20_P=W_OTA20_P W_OTA6_N=W_OTA6_N W_OTA6_P=W_OTA6_P
  C1a (vinp_stage1 vinn_stage1) capacitor c=C1
  C1b (vinn_stage1 vinp_stage1) capacitor c=C1
  C2a (vinp_stage2 vinn_stage2) capacitor c=C2
  C2b (vinn_stage2 vinp_stage2) capacitor c=C2
  C3a (voutn vinp_ota) capacitor c=C3
  C3b (voutp vinn_ota) capacitor c=C3
  x2 (vinp_stage1 vinp VSS) iqmod_mfb_lpf_R1 R1=R1
  x3 (vinn_stage1 vinn VSS) iqmod_mfb_lpf_R1 R1=R1
  x4 (vinp_stage1 vinp_stage2 VSS) iqmod_mfb_lpf_R2 R2=R2
  x5 (vinn_stage1 vinn_stage2 VSS) iqmod_mfb_lpf_R2 R2=R2
  x6 (vinp_ota vinp_stage2 VSS) iqmod_mfb_lpf_R3 R3=R3
  x7 (vinn_ota vinn_stage2 VSS) iqmod_mfb_lpf_R3 R3=R3
  x8 (voutn vinp_stage2 VSS) iqmod_mfb_lpf_R4 R4=R4
  x9 (voutp vinn_stage2 VSS) iqmod_mfb_lpf_R4 R4=R4
ends iqmod_mfb_lpf
subckt iqmod_mixer (vinp_IF vinn_IF voutp_RF vinp_LO vinn_LO VDD VSS voutn_RF)
  parameters L_MIXDM_N=1e-06 L_MIXDM_P=1e-06 L_MIXTG_N=1e-06 L_MIXTG_P=1e-06 M_MIXDM_N=1.0 M_MIXDM_P=1.0 M_MIXTG_N=1.0 M_MIXTG_P=1.0 NF_MIXDM_N=1.0 NF_MIXDM_P=1.0 NF_MIXTG_N=1.0 NF_MIXTG_P=1.0 W_MIXDM_N=1e-06 W_MIXDM_P=1e-06 W_MIXTG_N=1e-06 W_MIXTG_P=1e-06
  x2 (VDD vinp_LO_buf VSS voutp_RF vinp_IF vinp_LO_inv) iqmod_mixer_tg L_MIXDM_N=L_MIXDM_N L_MIXDM_P=L_MIXDM_P L_MIXTG_N=L_MIXTG_N L_MIXTG_P=L_MIXTG_P M_MIXDM_N=M_MIXDM_N M_MIXDM_P=M_MIXDM_P M_MIXTG_N=M_MIXTG_N M_MIXTG_P=M_MIXTG_P NF_MIXDM_N=NF_MIXDM_N NF_MIXDM_P=NF_MIXDM_P NF_MIXTG_N=NF_MIXTG_N NF_MIXTG_P=NF_MIXTG_P W_MIXDM_N=W_MIXDM_N W_MIXDM_P=W_MIXDM_P W_MIXTG_N=W_MIXTG_N W_MIXTG_P=W_MIXTG_P
  x4 (VDD vinn_LO_buf VSS voutn_RF vinn_IF vinn_LO_inv) iqmod_mixer_tg L_MIXDM_N=L_MIXDM_N L_MIXDM_P=L_MIXDM_P L_MIXTG_N=L_MIXTG_N L_MIXTG_P=L_MIXTG_P M_MIXDM_N=M_MIXDM_N M_MIXDM_P=M_MIXDM_P M_MIXTG_N=M_MIXTG_N M_MIXTG_P=M_MIXTG_P NF_MIXDM_N=NF_MIXDM_N NF_MIXDM_P=NF_MIXDM_P NF_MIXTG_N=NF_MIXTG_N NF_MIXTG_P=NF_MIXTG_P W_MIXDM_N=W_MIXDM_N W_MIXDM_P=W_MIXDM_P W_MIXTG_N=W_MIXTG_N W_MIXTG_P=W_MIXTG_P
  x1 (VDD vinp_LO vinp_LO_buf VSS vinp_LO_inv) iqmod_mixer_se2diff
  x3 (VDD vinn_LO vinn_LO_buf VSS vinn_LO_inv) iqmod_mixer_se2diff
ends iqmod_mixer
subckt iqmod_top_half (di_ds_p di_spdt_ctrl di_ds_n di_lo_p di_lo_n voutp_RF vinp vinn voutn_RF VDD VSS di_analog_en)
  parameters C1=1e-12 C2=1e-12 C3=1e-12 L_MIXDM_N=1e-06 L_MIXDM_P=1e-06 L_MIXTG_N=1e-06 L_MIXTG_P=1e-06 L_OTA10_N=1e-06 L_OTA10_P=1e-06 L_OTA20_N=1e-06 L_OTA20_P=1e-06 L_OTA6_N=1e-06 L_OTA6_P=1e-06 M_MIXDM_N=1.0 M_MIXDM_P=1.0 M_MIXTG_N=1.0 M_MIXTG_P=1.0 M_OTA10_N=1.0 M_OTA10_P=1.0 M_OTA20_N=1.0 M_OTA20_P=1.0 M_OTA6_N=1.0 M_OTA6_P=1.0 NF_MIXDM_N=1.0 NF_MIXDM_P=1.0 NF_MIXTG_N=1.0 NF_MIXTG_P=1.0 NF_OTA10_N=1.0 NF_OTA10_P=1.0 NF_OTA20_N=1.0 NF_OTA20_P=1.0 NF_OTA6_N=1.0 NF_OTA6_P=1.0 R1=10000.0 R2=10000.0 R3=10000.0 R4=10000.0 W_MIXDM_N=1e-06 W_MIXDM_P=1e-06 W_MIXTG_N=1e-06 W_MIXTG_P=1e-06 W_OTA10_N=1e-06 W_OTA10_P=1e-06 W_OTA20_N=1e-06 W_OTA20_P=1e-06 W_OTA6_N=1e-06 W_OTA6_P=1e-06
  x3 (voutp_lpf voutn_lpf voutp_RF di_lo_p di_lo_n VDD VSS voutn_RF) iqmod_mixer L_MIXDM_N=L_MIXDM_N L_MIXDM_P=L_MIXDM_P L_MIXTG_N=L_MIXTG_N L_MIXTG_P=L_MIXTG_P M_MIXDM_N=M_MIXDM_N M_MIXDM_P=M_MIXDM_P M_MIXTG_N=M_MIXTG_N M_MIXTG_P=M_MIXTG_P NF_MIXDM_N=NF_MIXDM_N NF_MIXDM_P=NF_MIXDM_P NF_MIXTG_N=NF_MIXTG_N NF_MIXTG_P=NF_MIXTG_P W_MIXDM_N=W_MIXDM_N W_MIXDM_P=W_MIXDM_P W_MIXTG_N=W_MIXTG_N W_MIXTG_P=W_MIXTG_P
  x1 (voutp_lpf vinp_spdt voutn_lpf vinn_spdt VDD VSS di_analog_en) iqmod_mfb_lpf C1=C1 C2=C2 C3=C3 L_OTA10_N=L_OTA10_N L_OTA10_P=L_OTA10_P L_OTA20_N=L_OTA20_N L_OTA20_P=L_OTA20_P L_OTA6_N=L_OTA6_N L_OTA6_P=L_OTA6_P M_OTA10_N=M_OTA10_N M_OTA10_P=M_OTA10_P M_OTA20_N=M_OTA20_N M_OTA20_P=M_OTA20_P M_OTA6_N=M_OTA6_N M_OTA6_P=M_OTA6_P NF_OTA10_N=NF_OTA10_N NF_OTA10_P=NF_OTA10_P NF_OTA20_N=NF_OTA20_N NF_OTA20_P=NF_OTA20_P NF_OTA6_N=NF_OTA6_N NF_OTA6_P=NF_OTA6_P R1=R1 R2=R2 R3=R3 R4=R4 W_OTA10_N=W_OTA10_N W_OTA10_P=W_OTA10_P W_OTA20_N=W_OTA20_N W_OTA20_P=W_OTA20_P W_OTA6_N=W_OTA6_N W_OTA6_P=W_OTA6_P
  x5 (VDD di_spdt_ctrl VSS vinp_spdt di_ds_p vinp) iqmod_spdt_switch
  x6 (VDD di_spdt_ctrl VSS vinn_spdt di_ds_n vinn) iqmod_spdt_switch
ends iqmod_top_half
subckt iqmod_top (di_ds_I_p di_spdt_ctrl_I di_ds_I_n di_ds_Q_n di_spdt_ctrl_Q di_ds_Q_p vinp_Q vinn_Q di_lo_I di_lo_Ix voutp_I_RF vinp_I vinn_I di_lo_Q di_lo_Qx voutn_I_RF voutp_Q_RF voutn_Q_RF VDD VSS di_analog_en)
  parameters C1=1e-12 C2=1e-12 C3=1e-12 L_MIXDM_N=1e-06 L_MIXDM_P=1e-06 L_MIXTG_N=1e-06 L_MIXTG_P=1e-06 L_OTA10_N=1e-06 L_OTA10_P=1e-06 L_OTA20_N=1e-06 L_OTA20_P=1e-06 L_OTA6_N=1e-06 L_OTA6_P=1e-06 M_MIXDM_N=1.0 M_MIXDM_P=1.0 M_MIXTG_N=1.0 M_MIXTG_P=1.0 M_OTA10_N=1.0 M_OTA10_P=1.0 M_OTA20_N=1.0 M_OTA20_P=1.0 M_OTA6_N=1.0 M_OTA6_P=1.0 NF_MIXDM_N=1.0 NF_MIXDM_P=1.0 NF_MIXTG_N=1.0 NF_MIXTG_P=1.0 NF_OTA10_N=1.0 NF_OTA10_P=1.0 NF_OTA20_N=1.0 NF_OTA20_P=1.0 NF_OTA6_N=1.0 NF_OTA6_P=1.0 R1=10000.0 R2=10000.0 R3=10000.0 R4=10000.0 W_MIXDM_N=1e-06 W_MIXDM_P=1e-06 W_MIXTG_N=1e-06 W_MIXTG_P=1e-06 W_OTA10_N=1e-06 W_OTA10_P=1e-06 W_OTA20_N=1e-06 W_OTA20_P=1e-06 W_OTA6_N=1e-06 W_OTA6_P=1e-06
  x1 (di_ds_I_p di_spdt_ctrl_I di_ds_I_n di_lo_I di_lo_Ix voutp_I_RF vinp_I vinn_I voutn_I_RF VDD VSS di_analog_en) iqmod_top_half C1=C1 C2=C2 C3=C3 L_MIXDM_N=L_MIXDM_N L_MIXDM_P=L_MIXDM_P L_MIXTG_N=L_MIXTG_N L_MIXTG_P=L_MIXTG_P L_OTA10_N=L_OTA10_N L_OTA10_P=L_OTA10_P L_OTA20_N=L_OTA20_N L_OTA20_P=L_OTA20_P L_OTA6_N=L_OTA6_N L_OTA6_P=L_OTA6_P M_MIXDM_N=M_MIXDM_N M_MIXDM_P=M_MIXDM_P M_MIXTG_N=M_MIXTG_N M_MIXTG_P=M_MIXTG_P M_OTA10_N=M_OTA10_N M_OTA10_P=M_OTA10_P M_OTA20_N=M_OTA20_N M_OTA20_P=M_OTA20_P M_OTA6_N=M_OTA6_N M_OTA6_P=M_OTA6_P NF_MIXDM_N=NF_MIXDM_N NF_MIXDM_P=NF_MIXDM_P NF_MIXTG_N=NF_MIXTG_N NF_MIXTG_P=NF_MIXTG_P NF_OTA10_N=NF_OTA10_N NF_OTA10_P=NF_OTA10_P NF_OTA20_N=NF_OTA20_N NF_OTA20_P=NF_OTA20_P NF_OTA6_N=NF_OTA6_N NF_OTA6_P=NF_OTA6_P R1=R1 R2=R2 R3=R3 R4=R4 W_MIXDM_N=W_MIXDM_N W_MIXDM_P=W_MIXDM_P W_MIXTG_N=W_MIXTG_N W_MIXTG_P=W_MIXTG_P W_OTA10_N=W_OTA10_N W_OTA10_P=W_OTA10_P W_OTA20_N=W_OTA20_N W_OTA20_P=W_OTA20_P W_OTA6_N=W_OTA6_N W_OTA6_P=W_OTA6_P
  x2 (di_ds_Q_p di_spdt_ctrl_Q di_ds_Q_n di_lo_Q di_lo_Qx voutp_Q_RF vinp_Q vinn_Q voutn_Q_RF VDD VSS di_analog_en) iqmod_top_half C1=C1 C2=C2 C3=C3 L_MIXDM_N=L_MIXDM_N L_MIXDM_P=L_MIXDM_P L_MIXTG_N=L_MIXTG_N L_MIXTG_P=L_MIXTG_P L_OTA10_N=L_OTA10_N L_OTA10_P=L_OTA10_P L_OTA20_N=L_OTA20_N L_OTA20_P=L_OTA20_P L_OTA6_N=L_OTA6_N L_OTA6_P=L_OTA6_P M_MIXDM_N=M_MIXDM_N M_MIXDM_P=M_MIXDM_P M_MIXTG_N=M_MIXTG_N M_MIXTG_P=M_MIXTG_P M_OTA10_N=M_OTA10_N M_OTA10_P=M_OTA10_P M_OTA20_N=M_OTA20_N M_OTA20_P=M_OTA20_P M_OTA6_N=M_OTA6_N M_OTA6_P=M_OTA6_P NF_MIXDM_N=NF_MIXDM_N NF_MIXDM_P=NF_MIXDM_P NF_MIXTG_N=NF_MIXTG_N NF_MIXTG_P=NF_MIXTG_P NF_OTA10_N=NF_OTA10_N NF_OTA10_P=NF_OTA10_P NF_OTA20_N=NF_OTA20_N NF_OTA20_P=NF_OTA20_P NF_OTA6_N=NF_OTA6_N NF_OTA6_P=NF_OTA6_P R1=R1 R2=R2 R3=R3 R4=R4 W_MIXDM_N=W_MIXDM_N W_MIXDM_P=W_MIXDM_P W_MIXTG_N=W_MIXTG_N W_MIXTG_P=W_MIXTG_P W_OTA10_N=W_OTA10_N W_OTA10_P=W_OTA10_P W_OTA20_N=W_OTA20_N W_OTA20_P=W_OTA20_P W_OTA6_N=W_OTA6_N W_OTA6_P=W_OTA6_P
ends iqmod_top
subckt tinywhisper24_iqmod_dut (di_ds_I_p di_spdt_ctrl_I di_ds_I_n di_ds_Q_n di_spdt_ctrl_Q di_ds_Q_p vinp_Q vinn_Q di_lo_I di_lo_Ix voutp_I_RF vinp_I vinn_I di_lo_Q di_lo_Qx voutn_I_RF voutp_Q_RF voutn_Q_RF VDD VSS di_analog_en)
parameters W_OTA6_N=1e-06 L_OTA6_N=1e-06 NF_OTA6_N=1.0 W_OTA6_P=1e-06 L_OTA6_P=1e-06 NF_OTA6_P=1.0 W_OTA10_N=1e-06 L_OTA10_N=1e-06 NF_OTA10_N=1.0 W_OTA10_P=1e-06 L_OTA10_P=1e-06 NF_OTA10_P=1.0 W_OTA20_N=1e-06 L_OTA20_N=1e-06 NF_OTA20_N=1.0 W_OTA20_P=1e-06 L_OTA20_P=1e-06 NF_OTA20_P=1.0 W_MIXTG_N=1e-06 L_MIXTG_N=1e-06 NF_MIXTG_N=1.0 W_MIXTG_P=1e-06 L_MIXTG_P=1e-06 NF_MIXTG_P=1.0 W_MIXDM_N=1e-06 L_MIXDM_N=1e-06 NF_MIXDM_N=1.0 W_MIXDM_P=1e-06 L_MIXDM_P=1e-06 NF_MIXDM_P=1.0 R1=10000.0 R2=10000.0 R3=10000.0 R4=10000.0 C1=1e-12 C2=1e-12 C3=1e-12 M_OTA6_N=1.0 M_OTA6_P=1.0 M_OTA10_N=1.0 M_OTA10_P=1.0 M_OTA20_N=1.0 M_OTA20_P=1.0 M_MIXTG_N=1.0 M_MIXTG_P=1.0 M_MIXDM_N=1.0 M_MIXDM_P=1.0 W_SPDT_INV_N=1.153846154 W_SPDT_INV_P=6.923076923 W_SPDT_TG_N=1.153846154 W_SPDT_TG_P=6.923076923 W_LOTG_N=1.153846154 W_LOTG_P=3.461538462 W_LO2_N=1.153846154 W_LO2_P=3.461538462 W_LO6_N=1.153846154 W_LO6_P=3.461538462 W_LO18_N=1.153846154 W_LO18_P=3.461538462 W_LO54_N=1.153846154 W_LO54_P=3.461538462
xiqmod_top (di_ds_I_p di_spdt_ctrl_I di_ds_I_n di_ds_Q_n di_spdt_ctrl_Q di_ds_Q_p vinp_Q vinn_Q di_lo_I di_lo_Ix voutp_I_RF vinp_I vinn_I di_lo_Q di_lo_Qx voutn_I_RF voutp_Q_RF voutn_Q_RF VDD VSS di_analog_en) iqmod_top C1=C1 C2=C2 C3=C3 L_MIXDM_N=L_MIXDM_N L_MIXDM_P=L_MIXDM_P L_MIXTG_N=L_MIXTG_N L_MIXTG_P=L_MIXTG_P L_OTA10_N=L_OTA10_N L_OTA10_P=L_OTA10_P L_OTA20_N=L_OTA20_N L_OTA20_P=L_OTA20_P L_OTA6_N=L_OTA6_N L_OTA6_P=L_OTA6_P M_MIXDM_N=M_MIXDM_N M_MIXDM_P=M_MIXDM_P M_MIXTG_N=M_MIXTG_N M_MIXTG_P=M_MIXTG_P M_OTA10_N=M_OTA10_N M_OTA10_P=M_OTA10_P M_OTA20_N=M_OTA20_N M_OTA20_P=M_OTA20_P M_OTA6_N=M_OTA6_N M_OTA6_P=M_OTA6_P NF_MIXDM_N=NF_MIXDM_N NF_MIXDM_P=NF_MIXDM_P NF_MIXTG_N=NF_MIXTG_N NF_MIXTG_P=NF_MIXTG_P NF_OTA10_N=NF_OTA10_N NF_OTA10_P=NF_OTA10_P NF_OTA20_N=NF_OTA20_N NF_OTA20_P=NF_OTA20_P NF_OTA6_N=NF_OTA6_N NF_OTA6_P=NF_OTA6_P R1=R1 R2=R2 R3=R3 R4=R4 W_MIXDM_N=W_MIXDM_N W_MIXDM_P=W_MIXDM_P W_MIXTG_N=W_MIXTG_N W_MIXTG_P=W_MIXTG_P W_OTA10_N=W_OTA10_N W_OTA10_P=W_OTA10_P W_OTA20_N=W_OTA20_N W_OTA20_P=W_OTA20_P W_OTA6_N=W_OTA6_N W_OTA6_P=W_OTA6_P
ends tinywhisper24_iqmod_dut
