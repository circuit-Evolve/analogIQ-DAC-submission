// analogiq 0.1.0 testbench - generated, do not edit
// task cmppl24_task_001  topology cmppl24_upcon2022
// recipe cmp_pl_offset_ramp_v1 v1  condition NN_T27_S1p00_MC (Monte Carlo mismatch, 20 samples, seed 1; models NN, 27 C, supply 1.8 V)
// request golden_cmppl24_task_001  candidate eca5dc39e87484f5
// execution profile search_full
simulator lang=spectre
global 0
include "<CADENCE_SHARED>/FOUNDRY/analog/180nm/models/spectre/gpdk.scs" section=stat
include "dut.scs"

parameters vdd_v=1.8 tclk=1e-09 tr=2e-11 cl=5e-15 vcm=0.9 vid=0.0

// Supply (the only source charged to the DUT energy metric).
VSUP (vdd 0) vsource dc=vdd_v
// Ideal clock: reset phase first; evaluating 50% edge at k*tclk + tclk/2 (paper Fig. 3: CLK high from 500 ps).
VCLK (clk 0) vsource type=pulse val0=0 val1=vdd_v delay=tclk/2-tr/2 rise=tr fall=tr width=tclk/2-tr period=tclk
// Pins driven by external_bias (VSS = 0 V) and the decision reference of the single-ended output.
VB_VSS (b_vss 0) vsource dc=0.0
VREFN (outn 0) vsource dc=vdd_v/2

// Staircase ramp of vid from -0.0195 V to 0.0195 V around vcm=0.9 V.
VINP (inp 0) vsource type=pwl wave=[0.0 0.89025 1.24e-09 0.89025 1.26e-09 0.89025 2.24e-09 0.89025 2.26e-09 0.89025 3.2400000000000004e-09 0.89025 3.2600000000000003e-09 0.89075 4.24e-09 0.89075 4.260000000000001e-09 0.89125 5.24e-09 0.89125 5.2600000000000004e-09 0.89175 6.240000000000001e-09 0.89175 6.260000000000001e-09 0.89225 7.240000000000001e-09 0.89225 7.260000000000001e-09 0.89275 8.240000000000001e-09 0.89275 8.260000000000001e-09 0.89325 9.240000000000002e-09 0.89325 9.260000000000002e-09 0.89375 1.0240000000000001e-08 0.89375 1.026e-08 0.89425 1.1240000000000002e-08 0.89425 1.1260000000000001e-08 0.89475 1.2240000000000002e-08 0.89475 1.2260000000000002e-08 0.89525 1.3240000000000001e-08 0.89525 1.3260000000000001e-08 0.89575 1.4240000000000002e-08 0.89575 1.4260000000000002e-08 0.89625 1.524e-08 0.89625 1.526e-08 0.89675 1.624e-08 0.89675 1.6259999999999998e-08 0.89725 1.7239999999999998e-08 0.89725 1.7259999999999997e-08 0.89775 1.824e-08 0.89775 1.826e-08 0.89825 1.924e-08 0.89825 1.926e-08 0.89875 2.0239999999999998e-08 0.89875 2.0259999999999997e-08 0.89925 2.124e-08 0.89925 2.126e-08 0.89975 2.224e-08 0.89975 2.226e-08 0.90025 2.3239999999999998e-08 0.90025 2.3259999999999998e-08 0.90075 2.424e-08 0.90075 2.426e-08 0.90125 2.524e-08 0.90125 2.526e-08 0.90175 2.624e-08 0.90175 2.6259999999999998e-08 0.90225 2.7239999999999998e-08 0.90225 2.7259999999999997e-08 0.90275 2.824e-08 0.90275 2.826e-08 0.90325 2.924e-08 0.90325 2.926e-08 0.90375 3.0240000000000005e-08 0.90375 3.026000000000001e-08 0.90425 3.124e-08 0.90425 3.126e-08 0.90475 3.224e-08 0.90475 3.2260000000000006e-08 0.90525 3.3240000000000005e-08 0.90525 3.326000000000001e-08 0.90575 3.424e-08 0.90575 3.4260000000000004e-08 0.90625 3.524e-08 0.90625 3.5260000000000006e-08 0.9067500000000001 3.6240000000000006e-08 0.9067500000000001 3.626000000000001e-08 0.90725 3.724e-08 0.90725 3.7260000000000004e-08 0.9077500000000001 3.8240000000000004e-08 0.9077500000000001 3.8260000000000006e-08 0.90825 3.9240000000000006e-08 0.90825 3.926000000000001e-08 0.9087500000000001 4.024e-08 0.9087500000000001 4.0260000000000004e-08 0.90925 4.1240000000000004e-08 0.90925 4.126000000000001e-08 0.9097500000000001]
VINN (inn 0) vsource type=pwl wave=[0.0 0.9097500000000001 1.24e-09 0.9097500000000001 1.26e-09 0.9097500000000001 2.24e-09 0.9097500000000001 2.26e-09 0.9097500000000001 3.2400000000000004e-09 0.9097500000000001 3.2600000000000003e-09 0.90925 4.24e-09 0.90925 4.260000000000001e-09 0.9087500000000001 5.24e-09 0.9087500000000001 5.2600000000000004e-09 0.90825 6.240000000000001e-09 0.90825 6.260000000000001e-09 0.9077500000000001 7.240000000000001e-09 0.9077500000000001 7.260000000000001e-09 0.90725 8.240000000000001e-09 0.90725 8.260000000000001e-09 0.9067500000000001 9.240000000000002e-09 0.9067500000000001 9.260000000000002e-09 0.90625 1.0240000000000001e-08 0.90625 1.026e-08 0.90575 1.1240000000000002e-08 0.90575 1.1260000000000001e-08 0.90525 1.2240000000000002e-08 0.90525 1.2260000000000002e-08 0.90475 1.3240000000000001e-08 0.90475 1.3260000000000001e-08 0.90425 1.4240000000000002e-08 0.90425 1.4260000000000002e-08 0.90375 1.524e-08 0.90375 1.526e-08 0.90325 1.624e-08 0.90325 1.6259999999999998e-08 0.90275 1.7239999999999998e-08 0.90275 1.7259999999999997e-08 0.90225 1.824e-08 0.90225 1.826e-08 0.90175 1.924e-08 0.90175 1.926e-08 0.90125 2.0239999999999998e-08 0.90125 2.0259999999999997e-08 0.90075 2.124e-08 0.90075 2.126e-08 0.90025 2.224e-08 0.90025 2.226e-08 0.89975 2.3239999999999998e-08 0.89975 2.3259999999999998e-08 0.89925 2.424e-08 0.89925 2.426e-08 0.89875 2.524e-08 0.89875 2.526e-08 0.89825 2.624e-08 0.89825 2.6259999999999998e-08 0.89775 2.7239999999999998e-08 0.89775 2.7259999999999997e-08 0.89725 2.824e-08 0.89725 2.826e-08 0.89675 2.924e-08 0.89675 2.926e-08 0.89625 3.0240000000000005e-08 0.89625 3.026000000000001e-08 0.89575 3.124e-08 0.89575 3.126e-08 0.89525 3.224e-08 0.89525 3.2260000000000006e-08 0.89475 3.3240000000000005e-08 0.89475 3.326000000000001e-08 0.89425 3.424e-08 0.89425 3.4260000000000004e-08 0.89375 3.524e-08 0.89375 3.5260000000000006e-08 0.89325 3.6240000000000006e-08 0.89325 3.626000000000001e-08 0.89275 3.724e-08 0.89275 3.7260000000000004e-08 0.89225 3.8240000000000004e-08 0.89225 3.8260000000000006e-08 0.89175 3.9240000000000006e-08 0.89175 3.926000000000001e-08 0.89125 4.024e-08 0.89125 4.0260000000000004e-08 0.89075 4.1240000000000004e-08 0.89075 4.126000000000001e-08 0.89025]

XDUT (vdd b_vss clk inp inn outp) cmppl24_dut L_B1N=2.2716351064342815e-07 L_B1P=1.8354989815794568e-07 L_B2N=2.5781169956795293e-07 L_B2P=4.198804937593894e-07 L_DN=7.416303648165462e-07 L_DP=2.5073108783123647e-07 L_DT=4.075788688585899e-07 L_IN=1.8496049373914e-07 L_IVN=2.0722503971729107e-07 L_IVP=2.0232616206488231e-07 L_NX=1.8539022712531696e-07 L_PX=2.254478683829309e-07 L_RSN=3.907913856742194e-07 L_RSP=5.16002755038464e-07 L_SWPQ=2.3474460677098146e-07 L_SWXY=7.197997094533754e-07 L_TAIL=2.253198119538474e-07 W_B1N=8.377656335003047e-07 W_B1P=1.417700450693859e-06 W_B2N=6.662144129651733e-07 W_B2P=1.9875106751814183e-06 W_DN=6.744669246046587e-07 W_DP=1.0223526514627396e-06 W_DT=1.1308113270681787e-06 W_IN=2.180097695320659e-05 W_IVN=7.427637559742304e-07 W_IVP=1.3828391033431987e-06 W_NX=3.6552700112107034e-06 W_PX=6.527450087097397e-07 W_RSN=1.1157864404072802e-06 W_RSP=4.1131116941262135e-07 W_SWPQ=3.7425540215549035e-06 W_SWXY=2.6290096240184055e-06 W_TAIL=1.21247680886762e-05
CLP (outp 0) capacitor c=cl

opts options temp=27.0 tnom=27 reltol=0.0001 save=selected
save clk inp inn outp outn VSUP:p VCLK:p XDUT.X XDUT.Y XDUT.P XDUT.Q XDUT.A XDUT.B XDUT.DEC XDUT.BUF

mcsamp montecarlo numruns=20 seed=1 variations=mismatch savefamilyplots=yes donominal=no {
tr1 tran stop=4.2250000000000004e-08 maxstep=2e-12 errpreset=moderate
}

simulator lang=spice
.include 'measures.sp'
.end
