// Golden sizing netlist (curator 2026-10-28): the benchmark DUT subckt with its parameter defaults set to
// the golden design (golden_design.json), taken from the verified run's job NN_T27_S1p00/cmp_pl_offset_ramp_v1.
// The DUT subckt and its parameter values are the same in every job of that run (only the testbench changes).
// Instance line of that run: XDUT (vdd b_vss clk inp inn outp) cmppl24_dut L_B1N=2.2716351064342815e-07 L_B1P=1.8354989815794568e-07 L_B2N=2.5781169956795293e-07 L_B2P=4.198804937593894e-07 L_DN=7.416303648165462e-07 L_DP=2.50731...
// Testbench-level variables (bias sources, operating levels) are in golden_design.json and testbench decks.
// Generated by analogiq from final.scs (sha256 5a7d124995243a4b).
// Connectivity and device models are unchanged except for the listed transformations:
//   - SW1: junction geometry ad/as/pd/ps rewritten in terms of the bound width (area = Lj*W, perimeter = 2*W + c; Lj and c from the netlist)
//   - SW3: junction geometry ad/as/pd/ps rewritten in terms of the bound width (area = Lj*W, perimeter = 2*W + c; Lj and c from the netlist)
//   - P5: junction geometry ad/as/pd/ps rewritten in terms of the bound width (area = Lj*W, perimeter = 2*W + c; Lj and c from the netlist)
//   - P6: junction geometry ad/as/pd/ps rewritten in terms of the bound width (area = Lj*W, perimeter = 2*W + c; Lj and c from the netlist)
//   - SW4: junction geometry ad/as/pd/ps rewritten in terms of the bound width (area = Lj*W, perimeter = 2*W + c; Lj and c from the netlist)
//   - SW2: junction geometry ad/as/pd/ps rewritten in terms of the bound width (area = Lj*W, perimeter = 2*W + c; Lj and c from the netlist)
//   - N3: junction geometry ad/as/pd/ps rewritten in terms of the bound width (area = Lj*W, perimeter = 2*W + c; Lj and c from the netlist)
//   - N4: junction geometry ad/as/pd/ps rewritten in terms of the bound width (area = Lj*W, perimeter = 2*W + c; Lj and c from the netlist)
//   - N1: junction geometry ad/as/pd/ps rewritten in terms of the bound width (area = Lj*W, perimeter = 2*W + c; Lj and c from the netlist)
//   - N2: junction geometry ad/as/pd/ps rewritten in terms of the bound width (area = Lj*W, perimeter = 2*W + c; Lj and c from the netlist)
//   - N7: junction geometry ad/as/pd/ps rewritten in terms of the bound width (area = Lj*W, perimeter = 2*W + c; Lj and c from the netlist)
//   - P9: junction geometry ad/as/pd/ps rewritten in terms of the bound width (area = Lj*W, perimeter = 2*W + c; Lj and c from the netlist)
//   - N8: junction geometry ad/as/pd/ps rewritten in terms of the bound width (area = Lj*W, perimeter = 2*W + c; Lj and c from the netlist)
//   - P10: junction geometry ad/as/pd/ps rewritten in terms of the bound width (area = Lj*W, perimeter = 2*W + c; Lj and c from the netlist)
//   - N11: junction geometry ad/as/pd/ps rewritten in terms of the bound width (area = Lj*W, perimeter = 2*W + c; Lj and c from the netlist)
//   - P12: junction geometry ad/as/pd/ps rewritten in terms of the bound width (area = Lj*W, perimeter = 2*W + c; Lj and c from the netlist)
//   - P13: junction geometry ad/as/pd/ps rewritten in terms of the bound width (area = Lj*W, perimeter = 2*W + c; Lj and c from the netlist)
//   - N14: junction geometry ad/as/pd/ps rewritten in terms of the bound width (area = Lj*W, perimeter = 2*W + c; Lj and c from the netlist)
//   - N15: junction geometry ad/as/pd/ps rewritten in terms of the bound width (area = Lj*W, perimeter = 2*W + c; Lj and c from the netlist)
//   - P19: junction geometry ad/as/pd/ps rewritten in terms of the bound width (area = Lj*W, perimeter = 2*W + c; Lj and c from the netlist)
//   - P20: junction geometry ad/as/pd/ps rewritten in terms of the bound width (area = Lj*W, perimeter = 2*W + c; Lj and c from the netlist)
//   - N16: junction geometry ad/as/pd/ps rewritten in terms of the bound width (area = Lj*W, perimeter = 2*W + c; Lj and c from the netlist)
//   - N17: junction geometry ad/as/pd/ps rewritten in terms of the bound width (area = Lj*W, perimeter = 2*W + c; Lj and c from the netlist)
//   - N18_tail: junction geometry ad/as/pd/ps rewritten in terms of the bound width (area = Lj*W, perimeter = 2*W + c; Lj and c from the netlist)
//   - P22: junction geometry ad/as/pd/ps rewritten in terms of the bound width (area = Lj*W, perimeter = 2*W + c; Lj and c from the netlist)
//   - N18_buf: junction geometry ad/as/pd/ps rewritten in terms of the bound width (area = Lj*W, perimeter = 2*W + c; Lj and c from the netlist)
//   - P23: junction geometry ad/as/pd/ps rewritten in terms of the bound width (area = Lj*W, perimeter = 2*W + c; Lj and c from the netlist)
//   - N19: junction geometry ad/as/pd/ps rewritten in terms of the bound width (area = Lj*W, perimeter = 2*W + c; Lj and c from the netlist)
//   - widths bound to sizing variables on fold-capable devices are folded symbolically into ceil(W/max) fingers of W/ceil(W/max) (per-device max [1e-05] m): N1, N11, N14, N15, N16, N17, N18_buf, N18_tail, N19, N2, N3, N4, N7, N8, P10, P12, P13, P19, P20, P22, P23, P5, P6, P9, SW1, SW2, SW3, SW4
subckt cmppl24_dut (VDD VSS CLK VP VN OUT)
parameters W_IN=2.180097695320659e-05 L_IN=1.8496049373914e-07 W_NX=3.6552700112107034e-06 L_NX=1.8539022712531696e-07 W_PX=6.527450087097397e-07 L_PX=2.254478683829309e-07 W_SWPQ=3.7425540215549035e-06 L_SWPQ=2.3474460677098146e-07 W_SWXY=2.6290096240184055e-06 L_SWXY=7.197997094533754e-07 W_TAIL=1.21247680886762e-05 L_TAIL=2.253198119538474e-07 W_IVP=1.3828391033431987e-06 L_IVP=2.0232616206488231e-07 W_IVN=7.427637559742304e-07 L_IVN=2.0722503971729107e-07 W_RSP=4.1131116941262135e-07 L_RSP=5.16002755038464e-07 W_RSN=1.1157864404072802e-06 L_RSN=3.907913856742194e-07 W_DP=1.0223526514627396e-06 L_DP=2.5073108783123647e-07 W_DN=6.744669246046587e-07 L_DN=7.416303648165462e-07 W_DT=1.1308113270681787e-06 L_DT=4.075788688585899e-07 W_B1P=1.417700450693859e-06 L_B1P=1.8354989815794568e-07 W_B1N=8.377656335003047e-07 L_B1N=2.2716351064342815e-07 W_B2P=1.9875106751814183e-06 L_B2P=4.198804937593894e-07 W_B2N=6.662144129651733e-07 L_B2N=2.5781169956795293e-07
SW1 (P CLK VDD VDD) pmos1 w=(W_SWPQ/max(1, W_SWPQ/1e-05)) l=L_SWPQ m=max(1, W_SWPQ/1e-05) ad=(6e-07*((W_SWPQ/max(1, W_SWPQ/1e-05)))) as=(6e-07*((W_SWPQ/max(1, W_SWPQ/1e-05)))) pd=max(2*((W_SWPQ/max(1, W_SWPQ/1e-05)))+(1.1999999999999987e-06),0) ps=max(2*((W_SWPQ/max(1, W_SWPQ/1e-05)))+(1.1999999999999987e-06),0)
SW3 (X CLK VDD VDD) pmos1 w=(W_SWXY/max(1, W_SWXY/1e-05)) l=L_SWXY m=max(1, W_SWXY/1e-05) ad=(6e-07*((W_SWXY/max(1, W_SWXY/1e-05)))) as=(6e-07*((W_SWXY/max(1, W_SWXY/1e-05)))) pd=max(2*((W_SWXY/max(1, W_SWXY/1e-05)))+(1.2000000000000004e-06),0) ps=max(2*((W_SWXY/max(1, W_SWXY/1e-05)))+(1.2000000000000004e-06),0)
P5 (X Y VDD VDD) pmos1 w=(W_PX/max(1, W_PX/1e-05)) l=L_PX m=max(1, W_PX/1e-05) ad=(6e-07*((W_PX/max(1, W_PX/1e-05)))) as=(6e-07*((W_PX/max(1, W_PX/1e-05)))) pd=max(2*((W_PX/max(1, W_PX/1e-05)))+(1.1999999999999987e-06),0) ps=max(2*((W_PX/max(1, W_PX/1e-05)))+(1.1999999999999987e-06),0)
P6 (Y X VDD VDD) pmos1 w=(W_PX/max(1, W_PX/1e-05)) l=L_PX m=max(1, W_PX/1e-05) ad=(6e-07*((W_PX/max(1, W_PX/1e-05)))) as=(6e-07*((W_PX/max(1, W_PX/1e-05)))) pd=max(2*((W_PX/max(1, W_PX/1e-05)))+(1.1999999999999987e-06),0) ps=max(2*((W_PX/max(1, W_PX/1e-05)))+(1.1999999999999987e-06),0)
SW4 (Y CLK VDD VDD) pmos1 w=(W_SWXY/max(1, W_SWXY/1e-05)) l=L_SWXY m=max(1, W_SWXY/1e-05) ad=(6e-07*((W_SWXY/max(1, W_SWXY/1e-05)))) as=(6e-07*((W_SWXY/max(1, W_SWXY/1e-05)))) pd=max(2*((W_SWXY/max(1, W_SWXY/1e-05)))+(1.2000000000000004e-06),0) ps=max(2*((W_SWXY/max(1, W_SWXY/1e-05)))+(1.2000000000000004e-06),0)
SW2 (Q CLK VDD VDD) pmos1 w=(W_SWPQ/max(1, W_SWPQ/1e-05)) l=L_SWPQ m=max(1, W_SWPQ/1e-05) ad=(6e-07*((W_SWPQ/max(1, W_SWPQ/1e-05)))) as=(6e-07*((W_SWPQ/max(1, W_SWPQ/1e-05)))) pd=max(2*((W_SWPQ/max(1, W_SWPQ/1e-05)))+(1.1999999999999987e-06),0) ps=max(2*((W_SWPQ/max(1, W_SWPQ/1e-05)))+(1.1999999999999987e-06),0)
N3 (X Y P VSS) nmos1 w=(W_NX/max(1, W_NX/1e-05)) l=L_NX m=max(1, W_NX/1e-05) ad=(6e-07*((W_NX/max(1, W_NX/1e-05)))) as=(6e-07*((W_NX/max(1, W_NX/1e-05)))) pd=max(2*((W_NX/max(1, W_NX/1e-05)))+(1.1999999999999987e-06),0) ps=max(2*((W_NX/max(1, W_NX/1e-05)))+(1.1999999999999987e-06),0)
N4 (Y X Q VSS) nmos1 w=(W_NX/max(1, W_NX/1e-05)) l=L_NX m=max(1, W_NX/1e-05) ad=(6e-07*((W_NX/max(1, W_NX/1e-05)))) as=(6e-07*((W_NX/max(1, W_NX/1e-05)))) pd=max(2*((W_NX/max(1, W_NX/1e-05)))+(1.1999999999999987e-06),0) ps=max(2*((W_NX/max(1, W_NX/1e-05)))+(1.1999999999999987e-06),0)
N1 (P VP TAIL VSS) nmos1 w=(W_IN/max(1, W_IN/1e-05)) l=L_IN m=max(1, W_IN/1e-05) ad=(6.000000000000001e-07*((W_IN/max(1, W_IN/1e-05)))) as=(6.000000000000001e-07*((W_IN/max(1, W_IN/1e-05)))) pd=max(2*((W_IN/max(1, W_IN/1e-05)))+(1.200000000000002e-06),0) ps=max(2*((W_IN/max(1, W_IN/1e-05)))+(1.200000000000002e-06),0)
N2 (Q VN TAIL VSS) nmos1 w=(W_IN/max(1, W_IN/1e-05)) l=L_IN m=max(1, W_IN/1e-05) ad=(6.000000000000001e-07*((W_IN/max(1, W_IN/1e-05)))) as=(6.000000000000001e-07*((W_IN/max(1, W_IN/1e-05)))) pd=max(2*((W_IN/max(1, W_IN/1e-05)))+(1.200000000000002e-06),0) ps=max(2*((W_IN/max(1, W_IN/1e-05)))+(1.200000000000002e-06),0)
N7 (TAIL CLK VSS VSS) nmos1 w=(W_TAIL/max(1, W_TAIL/1e-05)) l=L_TAIL m=max(1, W_TAIL/1e-05) ad=(6e-07*((W_TAIL/max(1, W_TAIL/1e-05)))) as=(6e-07*((W_TAIL/max(1, W_TAIL/1e-05)))) pd=max(2*((W_TAIL/max(1, W_TAIL/1e-05)))+(1.1999999999999987e-06),0) ps=max(2*((W_TAIL/max(1, W_TAIL/1e-05)))+(1.1999999999999987e-06),0)
P9 (XB X VDD VDD) pmos1 w=(W_IVP/max(1, W_IVP/1e-05)) l=L_IVP m=max(1, W_IVP/1e-05) ad=(6.000000000000001e-07*((W_IVP/max(1, W_IVP/1e-05)))) as=(6.000000000000001e-07*((W_IVP/max(1, W_IVP/1e-05)))) pd=max(2*((W_IVP/max(1, W_IVP/1e-05)))+(1.2e-06),0) ps=max(2*((W_IVP/max(1, W_IVP/1e-05)))+(1.2e-06),0)
N8 (XB X VSS VSS) nmos1 w=(W_IVN/max(1, W_IVN/1e-05)) l=L_IVN m=max(1, W_IVN/1e-05) ad=(6.000000000000001e-07*((W_IVN/max(1, W_IVN/1e-05)))) as=(6.000000000000001e-07*((W_IVN/max(1, W_IVN/1e-05)))) pd=max(2*((W_IVN/max(1, W_IVN/1e-05)))+(1.2e-06),0) ps=max(2*((W_IVN/max(1, W_IVN/1e-05)))+(1.2e-06),0)
P10 (YB Y VDD VDD) pmos1 w=(W_IVP/max(1, W_IVP/1e-05)) l=L_IVP m=max(1, W_IVP/1e-05) ad=(6.000000000000001e-07*((W_IVP/max(1, W_IVP/1e-05)))) as=(6.000000000000001e-07*((W_IVP/max(1, W_IVP/1e-05)))) pd=max(2*((W_IVP/max(1, W_IVP/1e-05)))+(1.2e-06),0) ps=max(2*((W_IVP/max(1, W_IVP/1e-05)))+(1.2e-06),0)
N11 (YB Y VSS VSS) nmos1 w=(W_IVN/max(1, W_IVN/1e-05)) l=L_IVN m=max(1, W_IVN/1e-05) ad=(6.000000000000001e-07*((W_IVN/max(1, W_IVN/1e-05)))) as=(6.000000000000001e-07*((W_IVN/max(1, W_IVN/1e-05)))) pd=max(2*((W_IVN/max(1, W_IVN/1e-05)))+(1.2e-06),0) ps=max(2*((W_IVN/max(1, W_IVN/1e-05)))+(1.2e-06),0)
P12 (A B VDD VDD) pmos1 w=(W_RSP/max(1, W_RSP/1e-05)) l=L_RSP m=max(1, W_RSP/1e-05) ad=(6.000000000000001e-07*((W_RSP/max(1, W_RSP/1e-05)))) as=(6.000000000000001e-07*((W_RSP/max(1, W_RSP/1e-05)))) pd=max(2*((W_RSP/max(1, W_RSP/1e-05)))+(1.2e-06),0) ps=max(2*((W_RSP/max(1, W_RSP/1e-05)))+(1.2e-06),0)
P13 (B A VDD VDD) pmos1 w=(W_RSP/max(1, W_RSP/1e-05)) l=L_RSP m=max(1, W_RSP/1e-05) ad=(6.000000000000001e-07*((W_RSP/max(1, W_RSP/1e-05)))) as=(6.000000000000001e-07*((W_RSP/max(1, W_RSP/1e-05)))) pd=max(2*((W_RSP/max(1, W_RSP/1e-05)))+(1.2e-06),0) ps=max(2*((W_RSP/max(1, W_RSP/1e-05)))+(1.2e-06),0)
N14 (A XB VSS VSS) nmos1 w=(W_RSN/max(1, W_RSN/1e-05)) l=L_RSN m=max(1, W_RSN/1e-05) ad=(6.000000000000001e-07*((W_RSN/max(1, W_RSN/1e-05)))) as=(6.000000000000001e-07*((W_RSN/max(1, W_RSN/1e-05)))) pd=max(2*((W_RSN/max(1, W_RSN/1e-05)))+(1.2e-06),0) ps=max(2*((W_RSN/max(1, W_RSN/1e-05)))+(1.2e-06),0)
N15 (B YB VSS VSS) nmos1 w=(W_RSN/max(1, W_RSN/1e-05)) l=L_RSN m=max(1, W_RSN/1e-05) ad=(6.000000000000001e-07*((W_RSN/max(1, W_RSN/1e-05)))) as=(6.000000000000001e-07*((W_RSN/max(1, W_RSN/1e-05)))) pd=max(2*((W_RSN/max(1, W_RSN/1e-05)))+(1.2e-06),0) ps=max(2*((W_RSN/max(1, W_RSN/1e-05)))+(1.2e-06),0)
P19 (DM DM VDD VDD) pmos1 w=(W_DP/max(1, W_DP/1e-05)) l=L_DP m=max(1, W_DP/1e-05) ad=(6.000000000000001e-07*((W_DP/max(1, W_DP/1e-05)))) as=(6.000000000000001e-07*((W_DP/max(1, W_DP/1e-05)))) pd=max(2*((W_DP/max(1, W_DP/1e-05)))+(1.2e-06),0) ps=max(2*((W_DP/max(1, W_DP/1e-05)))+(1.2e-06),0)
P20 (DEC DM VDD VDD) pmos1 w=(W_DP/max(1, W_DP/1e-05)) l=L_DP m=max(1, W_DP/1e-05) ad=(6.000000000000001e-07*((W_DP/max(1, W_DP/1e-05)))) as=(6.000000000000001e-07*((W_DP/max(1, W_DP/1e-05)))) pd=max(2*((W_DP/max(1, W_DP/1e-05)))+(1.2e-06),0) ps=max(2*((W_DP/max(1, W_DP/1e-05)))+(1.2e-06),0)
N16 (DM B DTAIL VSS) nmos1 w=(W_DN/max(1, W_DN/1e-05)) l=L_DN m=max(1, W_DN/1e-05) ad=(6.000000000000001e-07*((W_DN/max(1, W_DN/1e-05)))) as=(6.000000000000001e-07*((W_DN/max(1, W_DN/1e-05)))) pd=max(2*((W_DN/max(1, W_DN/1e-05)))+(1.2e-06),0) ps=max(2*((W_DN/max(1, W_DN/1e-05)))+(1.2e-06),0)
N17 (DEC A DTAIL VSS) nmos1 w=(W_DN/max(1, W_DN/1e-05)) l=L_DN m=max(1, W_DN/1e-05) ad=(6.000000000000001e-07*((W_DN/max(1, W_DN/1e-05)))) as=(6.000000000000001e-07*((W_DN/max(1, W_DN/1e-05)))) pd=max(2*((W_DN/max(1, W_DN/1e-05)))+(1.2e-06),0) ps=max(2*((W_DN/max(1, W_DN/1e-05)))+(1.2e-06),0)
N18_tail (DTAIL CLK VSS VSS) nmos1 w=(W_DT/max(1, W_DT/1e-05)) l=L_DT m=max(1, W_DT/1e-05) ad=(6.000000000000001e-07*((W_DT/max(1, W_DT/1e-05)))) as=(6.000000000000001e-07*((W_DT/max(1, W_DT/1e-05)))) pd=max(2*((W_DT/max(1, W_DT/1e-05)))+(1.2e-06),0) ps=max(2*((W_DT/max(1, W_DT/1e-05)))+(1.2e-06),0)
P22 (BUF DEC VDD VDD) pmos1 w=(W_B1P/max(1, W_B1P/1e-05)) l=L_B1P m=max(1, W_B1P/1e-05) ad=(6.000000000000001e-07*((W_B1P/max(1, W_B1P/1e-05)))) as=(6.000000000000001e-07*((W_B1P/max(1, W_B1P/1e-05)))) pd=max(2*((W_B1P/max(1, W_B1P/1e-05)))+(1.2e-06),0) ps=max(2*((W_B1P/max(1, W_B1P/1e-05)))+(1.2e-06),0)
N18_buf (BUF DEC VSS VSS) nmos1 w=(W_B1N/max(1, W_B1N/1e-05)) l=L_B1N m=max(1, W_B1N/1e-05) ad=(6.000000000000001e-07*((W_B1N/max(1, W_B1N/1e-05)))) as=(6.000000000000001e-07*((W_B1N/max(1, W_B1N/1e-05)))) pd=max(2*((W_B1N/max(1, W_B1N/1e-05)))+(1.2e-06),0) ps=max(2*((W_B1N/max(1, W_B1N/1e-05)))+(1.2e-06),0)
P23 (OUT BUF VDD VDD) pmos1 w=(W_B2P/max(1, W_B2P/1e-05)) l=L_B2P m=max(1, W_B2P/1e-05) ad=(6.000000000000001e-07*((W_B2P/max(1, W_B2P/1e-05)))) as=(6.000000000000001e-07*((W_B2P/max(1, W_B2P/1e-05)))) pd=max(2*((W_B2P/max(1, W_B2P/1e-05)))+(1.2e-06),0) ps=max(2*((W_B2P/max(1, W_B2P/1e-05)))+(1.2e-06),0)
N19 (OUT BUF VSS VSS) nmos1 w=(W_B2N/max(1, W_B2N/1e-05)) l=L_B2N m=max(1, W_B2N/1e-05) ad=(6.000000000000001e-07*((W_B2N/max(1, W_B2N/1e-05)))) as=(6.000000000000001e-07*((W_B2N/max(1, W_B2N/1e-05)))) pd=max(2*((W_B2N/max(1, W_B2N/1e-05)))+(1.2e-06),0) ps=max(2*((W_B2N/max(1, W_B2N/1e-05)))+(1.2e-06),0)
ends cmppl24_dut
