// analogiq 0.1.0 testbench - generated, do not edit
// task cmppl24_task_001  topology cmppl24_upcon2022
// recipe cmp_pl_offset_ramp_v1 v1  condition NN_T27_S1p00_MC (Monte Carlo mismatch, 20 samples, seed 1; models NN, 27 C, supply 1.8 V)
// request cmppl24_task_001__plan  candidate bc912d1d411273e7
// execution profile search_full
simulator lang=spectre
global 0
include "<CADENCE_SHARED>/FOUNDRY/analog/180nm/models/spectre/gpdk.scs" section=stat
include "dut.scs"

parameters vdd_v=1.8 tclk=1e-09 tr=2e-11 cl=5e-15 vcm=0.9 vid=0.0

// Supply (the only source charged to the DUT energy metric).
VSUP (vdd 0) vsource dc=vdd_v
// Ideal clock: reset phase first; evaluating 50% edge at k*tclk + tclk/2 (paper Fig. 3: CLK high from 500 ps).
VCLK (clk 0) vsource type=pulse val0=0 val1=vdd_v delay=tclk/2-tr/2 rise=tr fall=tr width=tclk/2-tr period=tclk
// Pins driven by external_bias (VSS = 0 V) and the decision reference of the single-ended output.
VB_VSS (b_vss 0) vsource dc=0.0
VREFN (outn 0) vsource dc=vdd_v/2

// Staircase ramp of vid from -0.0195 V to 0.0195 V around vcm=0.9 V.
VINP (inp 0) vsource type=pwl wave=[0.0 0.89025 1.24e-09 0.89025 1.26e-09 0.89025 2.24e-09 0.89025 2.26e-09 0.89025 3.2400000000000004e-09 0.89025 3.2600000000000003e-09 0.89075 4.24e-09 0.89075 4.260000000000001e-09 0.89125 5.24e-09 0.89125 5.2600000000000004e-09 0.89175 6.240000000000001e-09 0.89175 6.260000000000001e-09 0.89225 7.240000000000001e-09 0.89225 7.260000000000001e-09 0.89275 8.240000000000001e-09 0.89275 8.260000000000001e-09 0.89325 9.240000000000002e-09 0.89325 9.260000000000002e-09 0.89375 1.0240000000000001e-08 0.89375 1.026e-08 0.89425 1.1240000000000002e-08 0.89425 1.1260000000000001e-08 0.89475 1.2240000000000002e-08 0.89475 1.2260000000000002e-08 0.89525 1.3240000000000001e-08 0.89525 1.3260000000000001e-08 0.89575 1.4240000000000002e-08 0.89575 1.4260000000000002e-08 0.89625 1.524e-08 0.89625 1.526e-08 0.89675 1.624e-08 0.89675 1.6259999999999998e-08 0.89725 1.7239999999999998e-08 0.89725 1.7259999999999997e-08 0.89775 1.824e-08 0.89775 1.826e-08 0.89825 1.924e-08 0.89825 1.926e-08 0.89875 2.0239999999999998e-08 0.89875 2.0259999999999997e-08 0.89925 2.124e-08 0.89925 2.126e-08 0.89975 2.224e-08 0.89975 2.226e-08 0.90025 2.3239999999999998e-08 0.90025 2.3259999999999998e-08 0.90075 2.424e-08 0.90075 2.426e-08 0.90125 2.524e-08 0.90125 2.526e-08 0.90175 2.624e-08 0.90175 2.6259999999999998e-08 0.90225 2.7239999999999998e-08 0.90225 2.7259999999999997e-08 0.90275 2.824e-08 0.90275 2.826e-08 0.90325 2.924e-08 0.90325 2.926e-08 0.90375 3.0240000000000005e-08 0.90375 3.026000000000001e-08 0.90425 3.124e-08 0.90425 3.126e-08 0.90475 3.224e-08 0.90475 3.2260000000000006e-08 0.90525 3.3240000000000005e-08 0.90525 3.326000000000001e-08 0.90575 3.424e-08 0.90575 3.4260000000000004e-08 0.90625 3.524e-08 0.90625 3.5260000000000006e-08 0.9067500000000001 3.6240000000000006e-08 0.9067500000000001 3.626000000000001e-08 0.90725 3.724e-08 0.90725 3.7260000000000004e-08 0.9077500000000001 3.8240000000000004e-08 0.9077500000000001 3.8260000000000006e-08 0.90825 3.9240000000000006e-08 0.90825 3.926000000000001e-08 0.9087500000000001 4.024e-08 0.9087500000000001 4.0260000000000004e-08 0.90925 4.1240000000000004e-08 0.90925 4.126000000000001e-08 0.9097500000000001]
VINN (inn 0) vsource type=pwl wave=[0.0 0.9097500000000001 1.24e-09 0.9097500000000001 1.26e-09 0.9097500000000001 2.24e-09 0.9097500000000001 2.26e-09 0.9097500000000001 3.2400000000000004e-09 0.9097500000000001 3.2600000000000003e-09 0.90925 4.24e-09 0.90925 4.260000000000001e-09 0.9087500000000001 5.24e-09 0.9087500000000001 5.2600000000000004e-09 0.90825 6.240000000000001e-09 0.90825 6.260000000000001e-09 0.9077500000000001 7.240000000000001e-09 0.9077500000000001 7.260000000000001e-09 0.90725 8.240000000000001e-09 0.90725 8.260000000000001e-09 0.9067500000000001 9.240000000000002e-09 0.9067500000000001 9.260000000000002e-09 0.90625 1.0240000000000001e-08 0.90625 1.026e-08 0.90575 1.1240000000000002e-08 0.90575 1.1260000000000001e-08 0.90525 1.2240000000000002e-08 0.90525 1.2260000000000002e-08 0.90475 1.3240000000000001e-08 0.90475 1.3260000000000001e-08 0.90425 1.4240000000000002e-08 0.90425 1.4260000000000002e-08 0.90375 1.524e-08 0.90375 1.526e-08 0.90325 1.624e-08 0.90325 1.6259999999999998e-08 0.90275 1.7239999999999998e-08 0.90275 1.7259999999999997e-08 0.90225 1.824e-08 0.90225 1.826e-08 0.90175 1.924e-08 0.90175 1.926e-08 0.90125 2.0239999999999998e-08 0.90125 2.0259999999999997e-08 0.90075 2.124e-08 0.90075 2.126e-08 0.90025 2.224e-08 0.90025 2.226e-08 0.89975 2.3239999999999998e-08 0.89975 2.3259999999999998e-08 0.89925 2.424e-08 0.89925 2.426e-08 0.89875 2.524e-08 0.89875 2.526e-08 0.89825 2.624e-08 0.89825 2.6259999999999998e-08 0.89775 2.7239999999999998e-08 0.89775 2.7259999999999997e-08 0.89725 2.824e-08 0.89725 2.826e-08 0.89675 2.924e-08 0.89675 2.926e-08 0.89625 3.0240000000000005e-08 0.89625 3.026000000000001e-08 0.89575 3.124e-08 0.89575 3.126e-08 0.89525 3.224e-08 0.89525 3.2260000000000006e-08 0.89475 3.3240000000000005e-08 0.89475 3.326000000000001e-08 0.89425 3.424e-08 0.89425 3.4260000000000004e-08 0.89375 3.524e-08 0.89375 3.5260000000000006e-08 0.89325 3.6240000000000006e-08 0.89325 3.626000000000001e-08 0.89275 3.724e-08 0.89275 3.7260000000000004e-08 0.89225 3.8240000000000004e-08 0.89225 3.8260000000000006e-08 0.89175 3.9240000000000006e-08 0.89175 3.926000000000001e-08 0.89125 4.024e-08 0.89125 4.0260000000000004e-08 0.89075 4.1240000000000004e-08 0.89075 4.126000000000001e-08 0.89025]

XDUT (vdd b_vss clk inp inn outp) cmppl24_dut L_B1N={{L_B1N}} L_B1P={{L_B1P}} L_B2N={{L_B2N}} L_B2P={{L_B2P}} L_DN={{L_DN}} L_DP={{L_DP}} L_DT={{L_DT}} L_IN={{L_IN}} L_IVN={{L_IVN}} L_IVP={{L_IVP}} L_NX={{L_NX}} L_PX={{L_PX}} L_RSN={{L_RSN}} L_RSP={{L_RSP}} L_SWPQ={{L_SWPQ}} L_SWXY={{L_SWXY}} L_TAIL={{L_TAIL}} M_B1N={{M_B1N}} M_B1P={{M_B1P}} M_B2N={{M_B2N}} M_B2P={{M_B2P}} M_DN={{M_DN}} M_DP={{M_DP}} M_DT={{M_DT}} M_IN={{M_IN}} M_IVN={{M_IVN}} M_IVP={{M_IVP}} M_NX={{M_NX}} M_PX={{M_PX}} M_RSN={{M_RSN}} M_RSP={{M_RSP}} M_SWPQ={{M_SWPQ}} M_SWXY={{M_SWXY}} M_TAIL={{M_TAIL}} W_B1N={{W_B1N}} W_B1P={{W_B1P}} W_B2N={{W_B2N}} W_B2P={{W_B2P}} W_DN={{W_DN}} W_DP={{W_DP}} W_DT={{W_DT}} W_IN={{W_IN}} W_IVN={{W_IVN}} W_IVP={{W_IVP}} W_NX={{W_NX}} W_PX={{W_PX}} W_RSN={{W_RSN}} W_RSP={{W_RSP}} W_SWPQ={{W_SWPQ}} W_SWXY={{W_SWXY}} W_TAIL={{W_TAIL}}
CLP (outp 0) capacitor c=cl

opts options temp=27.0 tnom=27 reltol=0.0001 save=selected
save clk inp inn outp outn VSUP:p VCLK:p XDUT.X XDUT.Y XDUT.P XDUT.Q XDUT.A XDUT.B XDUT.DEC XDUT.BUF

mcsamp montecarlo numruns=20 seed=1 variations=mismatch savefamilyplots=yes donominal=no {
tr1 tran stop=4.2250000000000004e-08 maxstep=2e-12 errpreset=moderate
}

simulator lang=spice
.include 'measures.sp'
.end
