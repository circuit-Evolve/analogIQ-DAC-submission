// Design: DAC_20261107_MISO/VM_BP_TRAN_tb
simulator lang=spectre
global 0
include "<PDK_ROOT>/gpdk180/models/spectre/gpdk.scs" section=FS

// DAC_20261107_MISO/mdvccta_fig2/schematic
subckt mdvccta_fig2 GND N OM OP OP2 VBIAS VDD VSS X Y1 Y2 Z1P Z2P ZP
    M30 (Z2P VBIAS VSS VSS) nmos1 w=4.000000004e-07 l=8.37674756503e-07 m=1
    M29 (Z1P VBIAS VSS VSS) nmos1 w=4.000000004e-07 l=8.37674756503e-07 m=1
    M28 (ZP VBIAS VSS VSS) nmos1 w=4.000000004e-07 l=8.37674756503e-07 m=1
    M27 (X VBIAS VSS VSS) nmos1 w=4.000000004e-07 l=8.37674756503e-07 m=1
    M26 (T2 VBIAS VSS VSS) nmos1 w=4.12797070063e-06 l=1.89878554093e-06 m=1
    M25 (T1 VBIAS VSS VSS) nmos1 w=4.12797070063e-06 l=1.89878554093e-06 m=1
    M18 (NG Y1 T2 VSS) nmos1 w=1.03744922234e-05 l=5.90902019639e-07 m=1
    M17 (PG X T2 VSS) nmos1 w=1.03744922234e-05 l=5.90902019639e-07 m=1
    M16 (NG GND T1 VSS) nmos1 w=1.03744922234e-05 l=5.90902019639e-07 m=1
    M15 (PG Y2 T1 VSS) nmos1 w=1.03744922234e-05 l=5.90902019639e-07 m=1
    M14 (PB PB VSS VSS) nmos1 w=6.25480960835e-07 l=1.8e-07 m=1
    M13 (OP2 NB VSS VSS) nmos1 w=3.98093286488e-06 l=1.28847594535e-06 m=1
    M12 (OP NB VSS VSS) nmos1 w=3.98093286488e-06 l=1.28847594535e-06 m=1
    M11 (NB NB VSS VSS) nmos1 w=6.25480960835e-07 l=1.8e-07 m=1
    M10 (OM PB VSS VSS) nmos1 w=3.98093286488e-06 l=1.28847594535e-06 m=1
    M2 (NR ZP T VSS) nmos1 w=0.0001 l=1.8e-07 m=16
    M1 (NL N T VSS) nmos1 w=0.0001 l=1.8e-07 m=16
    M24 (Z2P NG VDD VDD) pmos1 w=6.33800580042e-06 l=2.84389087614e-07 m=1
    M23 (Z1P NG VDD VDD) pmos1 w=6.33800580042e-06 l=2.84389087614e-07 m=1
    M22 (ZP NG VDD VDD) pmos1 w=6.33800580042e-06 l=2.84389087614e-07 m=1
    M21 (X NG VDD VDD) pmos1 w=6.33800580042e-06 l=2.84389087614e-07 m=1
    M20 (NG PG VDD VDD) pmos1 w=8.54649363996e-06 l=1.8000000018e-07 m=1
    M19 (PG PG VDD VDD) pmos1 w=8.54649363996e-06 l=1.8000000018e-07 m=1
    M9 (PB NR VDD VDD) pmos1 w=1.41259139412e-05 l=1.22625502375e-06 m=3
    M8 (OP2 NR VDD VDD) pmos1 w=1.41259139412e-05 l=1.22625502375e-06 m=3
    M7 (OP NR VDD VDD) pmos1 w=1.41259139412e-05 l=1.22625502375e-06 m=3
    M6 (NR NR VDD VDD) pmos1 w=6.14192820657e-06 l=1.8e-07 m=1
    M5 (NL NL VDD VDD) pmos1 w=6.14192820657e-06 l=1.8e-07 m=1
    M4 (NB NL VDD VDD) pmos1 w=1.41259139412e-05 l=1.22625502375e-06 m=3
    M3 (OM NL VDD VDD) pmos1 w=1.41259139412e-05 l=1.22625502375e-06 m=3
    IBIAS (T VSS) isource dc=0.000146628282743 type=dc
ends mdvccta_fig2
subckt mdvccta_fig2_A1 GND N OM OP OP2 VBIAS VDD VSS X Y1 Y2 Z1P Z2P ZP
    M30 (Z2P VBIAS VSS VSS) nmos1 w=4.000000004e-07 l=8.37674756503e-07 m=1
    M29 (Z1P VBIAS VSS VSS) nmos1 w=4.000000004e-07 l=8.37674756503e-07 m=1
    M28 (ZP VBIAS VSS VSS) nmos1 w=4.000000004e-07 l=8.37674756503e-07 m=1
    M27 (X VBIAS VSS VSS) nmos1 w=4.000000004e-07 l=8.37674756503e-07 m=1
    M26 (T2 VBIAS VSS VSS) nmos1 w=4.12797070063e-06 l=1.89878554093e-06 m=1
    M25 (T1 VBIAS VSS VSS) nmos1 w=4.12797070063e-06 l=1.89878554093e-06 m=1
    M18 (NG Y1 T2 VSS) nmos1 w=1.03744922234e-05 l=5.90902019639e-07 m=1
    M17 (PG X T2 VSS) nmos1 w=1.03744922234e-05 l=5.90902019639e-07 m=1
    M16 (NG GND T1 VSS) nmos1 w=1.03744922234e-05 l=5.90902019639e-07 m=1
    M15 (PG Y2 T1 VSS) nmos1 w=1.03744922234e-05 l=5.90902019639e-07 m=1
    M14 (PB PB VSS VSS) nmos1 w=4.47731762394e-06 l=1.28847594535e-06 m=1
    M13 (OP2 NB VSS VSS) nmos1 w=4.47731762394e-06 l=1.28847594535e-06 m=1
    M12 (OP NB VSS VSS) nmos1 w=4.47731762394e-06 l=1.28847594535e-06 m=1
    M11 (NB NB VSS VSS) nmos1 w=4.47731762394e-06 l=1.28847594535e-06 m=1
    M10 (OM PB VSS VSS) nmos1 w=4.47731762394e-06 l=1.28847594535e-06 m=1
    M2 (NR ZP T VSS) nmos1 w=0.0001 l=1.8e-07 m=16
    M1 (NL N T VSS) nmos1 w=0.0001 l=1.8e-07 m=16
    M24 (Z2P NG VDD VDD) pmos1 w=6.33800580042e-06 l=2.84389087614e-07 m=1
    M23 (Z1P NG VDD VDD) pmos1 w=6.33800580042e-06 l=2.84389087614e-07 m=1
    M22 (ZP NG VDD VDD) pmos1 w=6.33800580042e-06 l=2.84389087614e-07 m=1
    M21 (X NG VDD VDD) pmos1 w=6.33800580042e-06 l=2.84389087614e-07 m=1
    M20 (NG PG VDD VDD) pmos1 w=8.54649363996e-06 l=1.8000000018e-07 m=1
    M19 (PG PG VDD VDD) pmos1 w=8.54649363996e-06 l=1.8000000018e-07 m=1
    M9 (PB NR VDD VDD) pmos1 w=5.92720633909e-06 l=1.22625502375e-06 m=1
    M8 (OP2 NR VDD VDD) pmos1 w=5.92720633909e-06 l=1.22625502375e-06 m=1
    M7 (OP NR VDD VDD) pmos1 w=5.92720633909e-06 l=1.22625502375e-06 m=1
    M6 (NR NR VDD VDD) pmos1 w=1.53548205164e-05 l=4.5e-07 m=1
    M5 (NL NL VDD VDD) pmos1 w=1.53548205164e-05 l=4.5e-07 m=1
    M4 (NB NL VDD VDD) pmos1 w=5.92720633909e-06 l=1.22625502375e-06 m=1
    M3 (OM NL VDD VDD) pmos1 w=5.92720633909e-06 l=1.22625502375e-06 m=1
    IBIAS (T VSS) isource dc=0.0004 type=dc
ends mdvccta_fig2_A1

// DAC_20261107_MISO/grounded_resistor_fig8a/schematic
subckt grounded_resistor_fig8a GND P VC
    MR2 (P VC GND GND) nmos1 w=9e-06 l=1.8e-05 m=1
    MR1 (P P GND GND) nmos1 w=9e-06 l=1.8e-05 m=1
ends grounded_resistor_fig8a
subckt grounded_resistor_fig8a_R2 GND P VC
    MR2 (P VC GND GND) nmos1 w=3.24074074074e-05 l=1.8e-05 m=1
    MR1 (P P GND GND) nmos1 w=3.24074074074e-05 l=1.8e-05 m=1
ends grounded_resistor_fig8a_R2

// DAC_20261107_MISO/miso_fig3/schematic
subckt miso_fig3 GND I1 I2 I3 IOUT V1 V2 V3 VBIAS VCTRL VDD VOUT VSS
    A2 (GND V1 I1 NOPB NOP2B VBIAS VDD VSS VOUT I1 GND IOUT NC2B I3) mdvccta_fig2
    A1 (GND V3 I3 NOPA NOP2A VBIAS VDD VSS X1 V2 I1 NC1A NC2A I2) mdvccta_fig2_A1
    R2 (GND VOUT VCTRL) grounded_resistor_fig8a_R2
    R1 (GND X1 VCTRL) grounded_resistor_fig8a
    R3 (I1 GND) resistor r=7245
    C2 (I3 GND) capacitor c=8.69830415595e-11
    C1 (I2 GND) capacitor c=4.34133486793e-12
ends miso_fig3

// DAC_20261107_MISO/VM_BP_TRAN_tb/schematic
DUT (0 I1 I2 I3 IOUT V1 V2 V3 VBIAS VCTRL VDD VOUT VSS) miso_fig3
IOUT_SRC (IOUT 0) vsource dc=0 mag=0 type=dc
V2_SRC (V2 0) vsource dc=0 mag=0 type=dc
V1_SRC (V1 0) vsource dc=0 mag=0 type=dc
VCTRL_SRC (VCTRL 0) vsource dc=0.90000000000000002 type=dc
VBIAS_SRC (VBIAS 0) vsource dc=0.49140457613450667 type=dc
VSS_SRC (VSS 0) vsource dc=-0.9 type=dc
VDD_SRC (VDD 0) vsource dc=0.9 type=dc
I3_SRC (0 I3) isource dc=0 type=dc
I2_SRC (0 I2) isource dc=0 type=dc
I1_SRC (0 I1) isource dc=0 type=dc
V3_SRC (V3 0) vsource type=sine sinedc=0 ampl=0.05 freq=3980000.0
simulatorOptions options reltol=1e-6 vabstol=1e-9 iabstol=1e-14 temp=27
saveOptions options currents=all subcktprobelvl=5
dcOp dc
tran tran stop=7.537688442211055e-06 maxstep=1.2562814070351758e-09 strobeperiod=9.814698492462311e-10 errpreset=conservative
