openResults("<WORK>/miso_iruwb_15pct_20261110/miso/nine_metric_sizing/ac_screens/compensated_final_v2_ac1200/TT/raw")
v=errset(cross(deriv(mag(getData("VOUT" ?result "ac"))) 0 1 "falling") t)
when(v && numberp(car(v)) printf("NINE_F0 TT %.17g\n" car(v)))
openResults("<WORK>/miso_iruwb_15pct_20261110/miso/nine_metric_sizing/ac_screens/compensated_final_v2_ac1200/FF/raw")
v=errset(cross(deriv(mag(getData("VOUT" ?result "ac"))) 0 1 "falling") t)
when(v && numberp(car(v)) printf("NINE_F0 FF %.17g\n" car(v)))
openResults("<WORK>/miso_iruwb_15pct_20261110/miso/nine_metric_sizing/ac_screens/compensated_final_v2_ac1200/SS/raw")
v=errset(cross(deriv(mag(getData("VOUT" ?result "ac"))) 0 1 "falling") t)
when(v && numberp(car(v)) printf("NINE_F0 SS %.17g\n" car(v)))
openResults("<WORK>/miso_iruwb_15pct_20261110/miso/nine_metric_sizing/ac_screens/compensated_final_v2_ac1200/SF/raw")
v=errset(cross(deriv(mag(getData("VOUT" ?result "ac"))) 0 1 "falling") t)
when(v && numberp(car(v)) printf("NINE_F0 SF %.17g\n" car(v)))
openResults("<WORK>/miso_iruwb_15pct_20261110/miso/nine_metric_sizing/ac_screens/compensated_final_v2_ac1200/FS/raw")
v=errset(cross(deriv(mag(getData("VOUT" ?result "ac"))) 0 1 "falling") t)
when(v && numberp(car(v)) printf("NINE_F0 FS %.17g\n" car(v)))
exit()
