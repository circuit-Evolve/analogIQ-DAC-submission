openResults("<WORK>/miso_iruwb_15pct_20261110/miso/nine_metric_sizing/full/compensated_final_v2/TT/VM_BP/raw")
v=errset(cross(deriv(mag(getData("VOUT" ?result "ac"))) 0 1 "falling") t)
when(v && numberp(car(v)) printf("MISO_SCALAR MISO_BP_frequency %.17g\n" car(v)))
openResults("<WORK>/miso_iruwb_15pct_20261110/miso/nine_metric_sizing/full/compensated_final_v2/TT/VM_LP_TRAN/raw")
v=errset(thd(getData("VOUT" ?result "tran") 2e-05 6e-05 8192 500000) t)
when(v && numberp(car(v)) printf("MISO_SCALAR LP_THD %.17g\n" car(v)))
openResults("<WORK>/miso_iruwb_15pct_20261110/miso/nine_metric_sizing/full/compensated_final_v2/TT/VM_BP_TRAN/raw")
v=errset(thd(getData("VOUT" ?result "tran") 2.51256281407e-06 7.53768844221e-06 8192 3980000) t)
when(v && numberp(car(v)) printf("MISO_SCALAR BP_THD %.17g\n" car(v)))
exit()
