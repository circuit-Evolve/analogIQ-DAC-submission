// Design: DAC_20261107_DTMOS/DTMOS_HPF_NOMINAL_tb
simulator lang=spectre
global 0
include "<PDK_ROOT>/gpdk180/models/spectre/gpdk.scs" section=NN

// DAC_20261107_DTMOS/dtmos_hpf_derived/schematic
subckt dtmos_hpf_derived GND IN OUT VDD VSS
    Mpb8_FB (IN PHP VDD VDD) pmos1 w=8u l=2u m=1
    Mpb6_FB (IN PLP VDD VDD) pmos1 w=40u l=0.5u m=1
    M3 (NB3 IN N1 VDD) pmos1 w=75u l=2u m=2
    Mpb8 (OUT PHP VDD VDD) pmos1 w=8u l=2u m=1
    Mpb7 (PHP PHP VDD VDD) pmos1 w=8u l=2u m=1
    Mpb6 (OUT PLP VDD VDD) pmos1 w=40u l=0.5u m=1
    Mpb5 (PLP PLP VDD VDD) pmos1 w=40u l=0.5u m=1
    Mpb4 (PB1 PB1 VDD PB1) pmos1 w=10u l=2u m=1
    Mpb3 (N2 PB1 VDD PB1) pmos1 w=10u l=2u m=1
    Mpb2 (PB2 PB2 VDD PB2) pmos1 w=10u l=2u m=1
    Mpb1 (N1 PB2 VDD PB2) pmos1 w=10u l=2u m=1
    Mnb5_FB (IN N1 VSS VSS) nmos1 w=10u l=0.2u m=1
    Mnb5 (OUT N1 VSS VSS) nmos1 w=10u l=0.2u m=1
    Mnb4 (PHP NB3 VSS VSS) nmos1 w=3u l=2u m=1
    Mnb3 (NB3 NB3 VSS VSS) nmos1 w=10u l=0.5u m=1
    Mnb2 (IN NB0 VSS VSS) nmos1 w=10u l=0.5u m=1
    Mnb1 (NB0 NB0 VSS VSS) nmos1 w=10u l=0.5u m=1
    M4 (VDD N2 IN VSS) nmos1 w=5u l=2u m=1
    M2 (PLP N2 GND VSS) nmos1 w=5u l=2u m=1
    M1 (N2 N1 VSS VSS) nmos1 w=3u l=2u m=1
    I0 (GND NB0) isource dc=60u type=dc
    IB2 (PB2 GND) isource dc=15u type=dc
    IB1 (PB1 GND) isource dc=250u type=dc
    C2 (N2 GND) capacitor c=120n
    C1 (N1 GND) capacitor c=70n
ends dtmos_hpf_derived

// DAC_20261107_DTMOS/DTMOS_HPF_NOMINAL_tb/schematic
DUT (0 IN OUT VDD VSS) dtmos_hpf_derived
VOUT_SENSE (OUT 0) vsource dc=0 type=dc
VSS_SRC (VSS 0) vsource dc=-.9 type=dc
VDD_SRC (VDD 0) vsource dc=.9 type=dc
IIN_SRC (0 IN) isource mag=1 type=sine sinedc=0 ampl=5u freq=500
simulatorOptions options reltol=1e-06 vabstol=1e-09 iabstol=1e-14 temp=27
tran tran stop=60m errpreset=conservative maxstep=2u strobeperiod=2u
ac ac start=1 stop=10M dec=100
dcOp dc
saveOptions options currents=all subcktprobelvl=5
