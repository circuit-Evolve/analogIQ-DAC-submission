// Design: DAC_20261107_MISO/CORE_IZP_tb
simulator lang=spectre
global 0
include "<PDK_ROOT>/gpdk180/models/spectre/gpdk.scs" section=NN

// DAC_20261107_MISO/mdvccta_fig2/schematic
subckt mdvccta_fig2 GND N OM OP OP2 VBIAS VDD VSS X Y1 Y2 Z1P Z2P ZP
    M30 (Z2P VBIAS VSS VSS) nmos1 w=1.58475531832e-05 l=8.84657504677e-07 m=1
    M29 (Z1P VBIAS VSS VSS) nmos1 w=1.58475531832e-05 l=8.84657504677e-07 m=1
    M28 (ZP VBIAS VSS VSS) nmos1 w=1.58475531832e-05 l=8.84657504677e-07 m=1
    M27 (X VBIAS VSS VSS) nmos1 w=1.58475531832e-05 l=8.84657504677e-07 m=1
    M26 (T2 VBIAS VSS VSS) nmos1 w=2.86922761021e-05 l=4.50691759025e-07 m=1
    M25 (T1 VBIAS VSS VSS) nmos1 w=2.86922761021e-05 l=4.50691759025e-07 m=1
    M18 (NG Y1 T2 VSS) nmos1 w=4.51407776618e-06 l=5.02478157682e-07 m=1
    M17 (PG X T2 VSS) nmos1 w=4.51407776618e-06 l=5.02478157682e-07 m=1
    M16 (NG GND T1 VSS) nmos1 w=4.51407776618e-06 l=5.02478157682e-07 m=1
    M15 (PG Y2 T1 VSS) nmos1 w=4.51407776618e-06 l=5.02478157682e-07 m=1
    M14 (PB PB VSS VSS) nmos1 w=1.49243920798e-06 l=1.28847594535e-06 m=1
    M13 (OP2 NB VSS VSS) nmos1 w=1.49243920798e-06 l=1.28847594535e-06 m=1
    M12 (OP NB VSS VSS) nmos1 w=1.49243920798e-06 l=1.28847594535e-06 m=1
    M11 (NB NB VSS VSS) nmos1 w=1.49243920798e-06 l=1.28847594535e-06 m=1
    M10 (OM PB VSS VSS) nmos1 w=1.49243920798e-06 l=1.28847594535e-06 m=1
    M2 (NR ZP T VSS) nmos1 w=9.04837787571e-07 l=5.13589896416e-07 m=1
    M1 (NL N T VSS) nmos1 w=9.04837787571e-07 l=5.13589896416e-07 m=1
    M24 (Z2P NG VDD VDD) pmos1 w=8.86237875649e-06 l=2.88393156491e-07 m=1
    M23 (Z1P NG VDD VDD) pmos1 w=8.86237875649e-06 l=2.88393156491e-07 m=1
    M22 (ZP NG VDD VDD) pmos1 w=8.86237875649e-06 l=2.88393156491e-07 m=1
    M21 (X NG VDD VDD) pmos1 w=8.86237875649e-06 l=2.88393156491e-07 m=1
    M20 (NG PG VDD VDD) pmos1 w=1.89973775423e-05 l=3.78010115234e-07 m=1
    M19 (PG PG VDD VDD) pmos1 w=1.89973775423e-05 l=3.78010115234e-07 m=1
    M9 (PB NR VDD VDD) pmos1 w=8.89015330868e-06 l=6.13127511873e-07 m=1
    M8 (OP2 NR VDD VDD) pmos1 w=8.89015330868e-06 l=6.13127511873e-07 m=1
    M7 (OP NR VDD VDD) pmos1 w=8.89015330868e-06 l=6.13127511873e-07 m=1
    M6 (NR NR VDD VDD) pmos1 w=1.92823064239e-06 l=4.52081501387e-07 m=1
    M5 (NL NL VDD VDD) pmos1 w=1.92823064239e-06 l=4.52081501387e-07 m=1
    M4 (NB NL VDD VDD) pmos1 w=8.89015330868e-06 l=6.13127511873e-07 m=1
    M3 (OM NL VDD VDD) pmos1 w=8.89015330868e-06 l=6.13127511873e-07 m=1
    IBIAS (T VSS) isource dc=6.10951178096e-05 type=dc
ends mdvccta_fig2

// DAC_20261107_MISO/CORE_IZP_tb/schematic
DUT (0 N OM OP OP2 VBIAS VDD VSS X Y1 Y2 Z1P Z2P ZP) mdvccta_fig2
OP2_SRC (OP2 0) vsource dc=0 mag=0 type=dc
OP_SRC (OP 0) vsource dc=0 mag=0 type=dc
OM_SRC (OM 0) vsource dc=0 mag=0 type=dc
Z2P_SRC (Z2P 0) vsource dc=0 mag=0 type=dc
Z1P_SRC (Z1P 0) vsource dc=0 mag=0 type=dc
ZP_SRC (ZP 0) vsource dc=0 mag=0 type=dc
N_SRC (N 0) vsource dc=0 mag=0 type=dc
Y2_SRC (Y2 0) vsource dc=0 mag=0 type=dc
Y1_SRC (Y1 0) vsource dc=0 mag=0 type=dc
VCTRL_SRC (VCTRL 0) vsource dc=0.7042596453528347 type=dc
VBIAS_SRC (VBIAS 0) vsource dc=-0.27567737156559907 type=dc
VSS_SRC (VSS 0) vsource dc=-0.9 type=dc
VDD_SRC (VDD 0) vsource dc=0.9 type=dc
IX_SRC (0 X) isource dc=0 mag=1 type=dc
simulatorOptions options reltol=1e-6 vabstol=1e-9 iabstol=1e-14 temp=27
saveOptions options currents=all subcktprobelvl=5
dcOp dc
ac ac start=1 stop=10G dec=150
ac_fine ac start=1.5G stop=1.65G lin=1501
range dc dev=IX_SRC param=dc start=-100u stop=100u step=.5u
