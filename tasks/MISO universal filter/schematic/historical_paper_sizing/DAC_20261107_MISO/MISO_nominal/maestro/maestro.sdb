ADE simulation setup
Tests:
  VM_LP: DAC_20261107_MISO/VM_LP_tb/schematic, simulator spectre
  VM_HP: DAC_20261107_MISO/VM_HP_tb/schematic, simulator spectre
  VM_BP: DAC_20261107_MISO/VM_BP_tb/schematic, simulator spectre
  VM_BR: DAC_20261107_MISO/VM_BR_tb/schematic, simulator spectre
  VM_AP: DAC_20261107_MISO/VM_AP_tb/schematic, simulator spectre
  CM_LP: DAC_20261107_MISO/CM_LP_tb/schematic, simulator spectre
  CM_HP: DAC_20261107_MISO/CM_HP_tb/schematic, simulator spectre
  CM_BP: DAC_20261107_MISO/CM_BP_tb/schematic, simulator spectre
  CM_BR: DAC_20261107_MISO/CM_BR_tb/schematic, simulator spectre
  CM_AP: DAC_20261107_MISO/CM_AP_tb/schematic, simulator spectre
  VM_LP_TRAN: DAC_20261107_MISO/VM_LP_TRAN_tb/schematic, simulator spectre
  VM_BP_TRAN: DAC_20261107_MISO/VM_BP_TRAN_tb/schematic, simulator spectre
  CORE_Y1: DAC_20261107_MISO/CORE_Y1_tb/schematic, simulator spectre
  CORE_Y2: DAC_20261107_MISO/CORE_Y2_tb/schematic, simulator spectre
  CORE_IZP: DAC_20261107_MISO/CORE_IZP_tb/schematic, simulator spectre
  CORE_RX: DAC_20261107_MISO/CORE_RX_tb/schematic, simulator spectre
  CORE_RZP: DAC_20261107_MISO/CORE_RZP_tb/schematic, simulator spectre
  CORE_ROP: DAC_20261107_MISO/CORE_ROP_tb/schematic, simulator spectre
  CORE_ROM: DAC_20261107_MISO/CORE_ROM_tb/schematic, simulator spectre
  CORE_GM: DAC_20261107_MISO/CORE_GM_tb/schematic, simulator spectre
