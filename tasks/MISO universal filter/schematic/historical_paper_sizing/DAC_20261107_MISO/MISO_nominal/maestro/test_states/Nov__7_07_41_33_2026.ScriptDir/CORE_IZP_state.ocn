design( "DAC_20261107_MISO" "CORE_IZP_tb" "schematic")
modelFile(
    '("<PDK_ROOT>/gpdk180/models/spectre/gpdk.scs" "NN")
)
analysis('ac ?start "1"  ?stop "10G"  ?dec "1500"  )
analysis('dc ?saveOppoint t  )
option(	'iabstol  "1e-14"
	'vabstol  "1e-09"
	'reltol  "1e-06"
)
saveOption( 'subcktprobelvl "5" )
saveOption( 'currents "all" )
temp( 27 )
