ADE simulation setup
Test CM_AP: DAC_20261107_MISO/CM_AP_tb/schematic, simulator spectre
  Output diagnostic_voltage_at3p98MHz = value(mag(getData("VOUT" ?result "ac")) 3980000.0)
  Output diagnostic_current_at3p98MHz = value(mag(getData("IOUT_SRC:p" ?result "ac")) 3980000.0)
Test CM_BP: DAC_20261107_MISO/CM_BP_tb/schematic, simulator spectre
  Output diagnostic_voltage_at3p98MHz = value(mag(getData("VOUT" ?result "ac")) 3980000.0)
  Output diagnostic_current_at3p98MHz = value(mag(getData("IOUT_SRC:p" ?result "ac")) 3980000.0)
Test CM_BR: DAC_20261107_MISO/CM_BR_tb/schematic, simulator spectre
  Output diagnostic_voltage_at3p98MHz = value(mag(getData("VOUT" ?result "ac")) 3980000.0)
  Output diagnostic_current_at3p98MHz = value(mag(getData("IOUT_SRC:p" ?result "ac")) 3980000.0)
Test CM_HP: DAC_20261107_MISO/CM_HP_tb/schematic, simulator spectre
  Output diagnostic_voltage_at3p98MHz = value(mag(getData("VOUT" ?result "ac")) 3980000.0)
  Output diagnostic_current_at3p98MHz = value(mag(getData("IOUT_SRC:p" ?result "ac")) 3980000.0)
Test CM_LP: DAC_20261107_MISO/CM_LP_tb/schematic, simulator spectre
  Output diagnostic_voltage_at3p98MHz = value(mag(getData("VOUT" ?result "ac")) 3980000.0)
  Output diagnostic_current_at3p98MHz = value(mag(getData("IOUT_SRC:p" ?result "ac")) 3980000.0)
Test CORE_IZP: DAC_20261107_MISO/CORE_IZP_tb/schematic, simulator spectre
  Output IZP_gain = value(mag(getData("ZP_SRC:p" ?result "ac")) 1)
  Output IZP_bandwidth = cross(mag(getData("ZP_SRC:p" ?result "ac")) (value(mag(getData("ZP_SRC:p" ?result "ac")) 1) / sqrt(2)) 1 "falling")
Test CORE_ROM: DAC_20261107_MISO/CORE_ROM_tb/schematic, simulator spectre
  Output ROM = value(real((-1 / getData("OM_SRC:p" ?result "ac"))) 1)
Test CORE_ROP: DAC_20261107_MISO/CORE_ROP_tb/schematic, simulator spectre
  Output ROP = value(real((-1 / getData("OP_SRC:p" ?result "ac"))) 1)
Test CORE_RX: DAC_20261107_MISO/CORE_RX_tb/schematic, simulator spectre
  Output RX = value(real(getData("X" ?result "ac")) 1)
Test CORE_RZP: DAC_20261107_MISO/CORE_RZP_tb/schematic, simulator spectre
  Output RZP = value(real((-1 / getData("ZP_SRC:p" ?result "ac"))) 1)
Test CORE_Y1: DAC_20261107_MISO/CORE_Y1_tb/schematic, simulator spectre
  Output Y1_gain = value(mag(getData("X" ?result "ac")) 1)
  Output Y1_bandwidth = cross(mag(getData("X" ?result "ac")) (value(mag(getData("X" ?result "ac")) 1) / sqrt(2)) 1 "falling")
Test CORE_Y2: DAC_20261107_MISO/CORE_Y2_tb/schematic, simulator spectre
  Output Y2_gain = value(mag(getData("X" ?result "ac")) 1)
  Output Y2_bandwidth = cross(mag(getData("X" ?result "ac")) (value(mag(getData("X" ?result "ac")) 1) / sqrt(2)) 1 "falling")
Test VM_AP: DAC_20261107_MISO/VM_AP_tb/schematic, simulator spectre
  Output diagnostic_voltage_at3p98MHz = value(mag(getData("VOUT" ?result "ac")) 3980000.0)
  Output diagnostic_current_at3p98MHz = value(mag(getData("IOUT_SRC:p" ?result "ac")) 3980000.0)
Test VM_BP: DAC_20261107_MISO/VM_BP_tb/schematic, simulator spectre
  Output MISO_BP_frequency = cross(deriv(mag(getData("VOUT" ?result "ac"))) 0 1 "falling")
  Output BP_noise_in = value(getData("in" ?result "noise") 3980000.0)
  Output BP_noise_out = value(getData("out" ?result "noise") 3980000.0)
  Output BP_gain_diagnostic = ymax(mag(getData("VOUT" ?result "ac")))
  Output diagnostic_voltage_at3p98MHz = value(mag(getData("VOUT" ?result "ac")) 3980000.0)
  Output diagnostic_current_at3p98MHz = value(mag(getData("IOUT_SRC:p" ?result "ac")) 3980000.0)
Test VM_BP_TRAN: DAC_20261107_MISO/VM_BP_TRAN_tb/schematic, simulator spectre
  Output BP_THD = thd(getData("VOUT" ?result "tran") 2.512563e-06 7.537688e-06 8192 3980000)
Test VM_BR: DAC_20261107_MISO/VM_BR_tb/schematic, simulator spectre
  Output diagnostic_voltage_at3p98MHz = value(mag(getData("VOUT" ?result "ac")) 3980000.0)
  Output diagnostic_current_at3p98MHz = value(mag(getData("IOUT_SRC:p" ?result "ac")) 3980000.0)
Test VM_HP: DAC_20261107_MISO/VM_HP_tb/schematic, simulator spectre
  Output diagnostic_voltage_at3p98MHz = value(mag(getData("VOUT" ?result "ac")) 3980000.0)
  Output diagnostic_current_at3p98MHz = value(mag(getData("IOUT_SRC:p" ?result "ac")) 3980000.0)
Test VM_LP: DAC_20261107_MISO/VM_LP_tb/schematic, simulator spectre
  Output MISO_quiescent_power = (0.9 * ((- getData("VDD_SRC:p" ?result "dcOp")) + getData("VSS_SRC:p" ?result "dcOp")))
  Output LP_gain_diagnostic = value(mag(getData("VOUT" ?result "ac")) 1)
  Output diagnostic_voltage_at3p98MHz = value(mag(getData("VOUT" ?result "ac")) 3980000.0)
  Output diagnostic_current_at3p98MHz = value(mag(getData("IOUT_SRC:p" ?result "ac")) 3980000.0)
Test VM_LP_TRAN: DAC_20261107_MISO/VM_LP_TRAN_tb/schematic, simulator spectre
  Output LP_THD = thd(getData("VOUT" ?result "tran") 2e-05 6e-05 8192 500000)
Test CORE_GM: DAC_20261107_MISO/CORE_GM_tb/schematic, simulator spectre
  Output OTA_gm = value(mag(getData("OM_SRC:p" ?result "ac")) 1)
