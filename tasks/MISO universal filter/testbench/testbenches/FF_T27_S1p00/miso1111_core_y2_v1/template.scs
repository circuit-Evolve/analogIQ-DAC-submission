// analogiq 0.1.0 testbench - generated, do not edit
// task miso_universal_111126_task_001  topology miso_universal_111126
// recipe miso1111_core_y2_v1 v1  condition FF_T27_S1p00 (models FF, 27 C, supply 0.9 V)
// request miso_universal_111126_task_001__plan  candidate 757e3058af5547ff
// execution profile search_full
simulator lang=spectre
global 0
include "<CADENCE_SHARED>/FOUNDRY/analog/180nm/models/spectre/gpdk.scs" section=FF
include "dut.scs"

parameters vsup=0.9 vneg=-0.9
// Sizing variables set in the testbench (external-bias values).
parameters V_BIAS={{V_BIAS}} V_CTRL={{V_CTRL}}
// Supplies and the core's bias (the filter's VBIAS).
VSUP (vdd 0) vsource dc=vsup
VNEG (vss 0) vsource dc=vneg
VB_VBIAS (c_vbias 0) vsource dc=V_BIAS
// CORE_Y2 fixture (replay deck): ports at 0 V except the driven one and X
VN_SRC (c_n 0) vsource dc=0
VOM_SRC (c_om 0) vsource dc=0
VOP_SRC (c_op 0) vsource dc=0
VOP2_SRC (c_op2 0) vsource dc=0
VY1_SRC (c_y1 0) vsource dc=0
VY2_SRC (c_y2 0) vsource dc=0 mag=1
VZ1P_SRC (c_z1p 0) vsource dc=0
VZ2P_SRC (c_z2p 0) vsource dc=0
VZP_SRC (c_zp 0) vsource dc=0
RXLOAD (c_x 0) resistor r=2000.0

XCORE (0 c_n c_om c_op c_op2 c_vbias vdd vss c_x c_y1 c_y2 c_z1p c_z2p c_zp) mdvccta_fig2 A2_IBIAS=1e-05 A2_L_IN=1e-06 A2_L_NDIO=1e-06 A2_L_NMIR=1e-06 A2_L_PLD=1e-06 A2_L_PMIR=1e-06 A2_M_IN=1.0 A2_M_NDIO=1.0 A2_M_NMIR=1.0 A2_M_PLD=1.0 A2_M_PMIR=1.0 A2_W_IN=1e-06 A2_W_NDIO=1e-06 A2_W_NMIR=1e-06 A2_W_PLD=1e-06 A2_W_PMIR=1e-06 FE_L_IN=1e-06 FE_L_NOUT=1e-06 FE_L_NTAIL=1e-06 FE_L_PMIR=1e-06 FE_L_POUT=1e-06 FE_M_IN=1.0 FE_M_NOUT=1.0 FE_M_NTAIL=1.0 FE_M_PMIR=1.0 FE_M_POUT=1.0 FE_W_IN=1e-06 FE_W_NOUT=1e-06 FE_W_NTAIL=1e-06 FE_W_PMIR=1e-06 FE_W_POUT=1e-06

opts options temp=27.0 tnom=27 reltol=0.0001 save=selected
save c_x VZP_SRC:p VSUP:p VNEG:p

ac1 ac start=1.0 stop=10.0 dec=1
