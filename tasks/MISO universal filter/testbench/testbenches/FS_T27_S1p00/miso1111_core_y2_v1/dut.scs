// Generated by analogiq from dut_benchmark.scs (sha256 3c5102ed0259acf0).
// Connectivity and device models are unchanged except for the listed transformations:
//   - ideal elements kept inside the DUT: IBIAS, IBIAS
//   - mdvccta_fig2.M30: junction geometry as/ad/ps/pd rewritten in terms of the bound width (area = Lj*W, perimeter = 2*W + c; Lj and c from the netlist)
//   - mdvccta_fig2.M29: junction geometry as/ad/ps/pd rewritten in terms of the bound width (area = Lj*W, perimeter = 2*W + c; Lj and c from the netlist)
//   - mdvccta_fig2.M28: junction geometry as/ad/ps/pd rewritten in terms of the bound width (area = Lj*W, perimeter = 2*W + c; Lj and c from the netlist)
//   - mdvccta_fig2.M27: junction geometry as/ad/ps/pd rewritten in terms of the bound width (area = Lj*W, perimeter = 2*W + c; Lj and c from the netlist)
//   - mdvccta_fig2.M26: junction geometry as/ad/ps/pd rewritten in terms of the bound width (area = Lj*W, perimeter = 2*W + c; Lj and c from the netlist)
//   - mdvccta_fig2.M25: junction geometry as/ad/ps/pd rewritten in terms of the bound width (area = Lj*W, perimeter = 2*W + c; Lj and c from the netlist)
//   - mdvccta_fig2.M18: junction geometry as/ad/ps/pd rewritten in terms of the bound width (area = Lj*W, perimeter = 2*W + c; Lj and c from the netlist)
//   - mdvccta_fig2.M17: junction geometry as/ad/ps/pd rewritten in terms of the bound width (area = Lj*W, perimeter = 2*W + c; Lj and c from the netlist)
//   - mdvccta_fig2.M16: junction geometry as/ad/ps/pd rewritten in terms of the bound width (area = Lj*W, perimeter = 2*W + c; Lj and c from the netlist)
//   - mdvccta_fig2.M15: junction geometry as/ad/ps/pd rewritten in terms of the bound width (area = Lj*W, perimeter = 2*W + c; Lj and c from the netlist)
//   - mdvccta_fig2.M14: junction geometry as/ad/ps/pd rewritten in terms of the bound width (area = Lj*W, perimeter = 2*W + c; Lj and c from the netlist)
//   - mdvccta_fig2.M13: junction geometry as/ad/ps/pd rewritten in terms of the bound width (area = Lj*W, perimeter = 2*W + c; Lj and c from the netlist)
//   - mdvccta_fig2.M12: junction geometry as/ad/ps/pd rewritten in terms of the bound width (area = Lj*W, perimeter = 2*W + c; Lj and c from the netlist)
//   - mdvccta_fig2.M11: junction geometry as/ad/ps/pd rewritten in terms of the bound width (area = Lj*W, perimeter = 2*W + c; Lj and c from the netlist)
//   - mdvccta_fig2.M10: junction geometry as/ad/ps/pd rewritten in terms of the bound width (area = Lj*W, perimeter = 2*W + c; Lj and c from the netlist)
//   - mdvccta_fig2.M2: junction geometry as/ad/ps/pd rewritten in terms of the bound width (area = Lj*W, perimeter = 2*W + c; Lj and c from the netlist)
//   - mdvccta_fig2.M1: junction geometry as/ad/ps/pd rewritten in terms of the bound width (area = Lj*W, perimeter = 2*W + c; Lj and c from the netlist)
//   - mdvccta_fig2.M24: junction geometry as/ad/ps/pd rewritten in terms of the bound width (area = Lj*W, perimeter = 2*W + c; Lj and c from the netlist)
//   - mdvccta_fig2.M23: junction geometry as/ad/ps/pd rewritten in terms of the bound width (area = Lj*W, perimeter = 2*W + c; Lj and c from the netlist)
//   - mdvccta_fig2.M22: junction geometry as/ad/ps/pd rewritten in terms of the bound width (area = Lj*W, perimeter = 2*W + c; Lj and c from the netlist)
//   - mdvccta_fig2.M21: junction geometry as/ad/ps/pd rewritten in terms of the bound width (area = Lj*W, perimeter = 2*W + c; Lj and c from the netlist)
//   - mdvccta_fig2.M20: junction geometry as/ad/ps/pd rewritten in terms of the bound width (area = Lj*W, perimeter = 2*W + c; Lj and c from the netlist)
//   - mdvccta_fig2.M19: junction geometry as/ad/ps/pd rewritten in terms of the bound width (area = Lj*W, perimeter = 2*W + c; Lj and c from the netlist)
//   - mdvccta_fig2.M9: junction geometry as/ad/ps/pd rewritten in terms of the bound width (area = Lj*W, perimeter = 2*W + c; Lj and c from the netlist)
//   - mdvccta_fig2.M8: junction geometry as/ad/ps/pd rewritten in terms of the bound width (area = Lj*W, perimeter = 2*W + c; Lj and c from the netlist)
//   - mdvccta_fig2.M7: junction geometry as/ad/ps/pd rewritten in terms of the bound width (area = Lj*W, perimeter = 2*W + c; Lj and c from the netlist)
//   - mdvccta_fig2.M6: junction geometry as/ad/ps/pd rewritten in terms of the bound width (area = Lj*W, perimeter = 2*W + c; Lj and c from the netlist)
//   - mdvccta_fig2.M5: junction geometry as/ad/ps/pd rewritten in terms of the bound width (area = Lj*W, perimeter = 2*W + c; Lj and c from the netlist)
//   - mdvccta_fig2.M4: junction geometry as/ad/ps/pd rewritten in terms of the bound width (area = Lj*W, perimeter = 2*W + c; Lj and c from the netlist)
//   - mdvccta_fig2.M3: junction geometry as/ad/ps/pd rewritten in terms of the bound width (area = Lj*W, perimeter = 2*W + c; Lj and c from the netlist)
//   - mdvccta_fig2_A1.M30: junction geometry as/ad/ps/pd rewritten in terms of the bound width (area = Lj*W, perimeter = 2*W + c; Lj and c from the netlist)
//   - mdvccta_fig2_A1.M29: junction geometry as/ad/ps/pd rewritten in terms of the bound width (area = Lj*W, perimeter = 2*W + c; Lj and c from the netlist)
//   - mdvccta_fig2_A1.M28: junction geometry as/ad/ps/pd rewritten in terms of the bound width (area = Lj*W, perimeter = 2*W + c; Lj and c from the netlist)
//   - mdvccta_fig2_A1.M27: junction geometry as/ad/ps/pd rewritten in terms of the bound width (area = Lj*W, perimeter = 2*W + c; Lj and c from the netlist)
//   - mdvccta_fig2_A1.M26: junction geometry as/ad/ps/pd rewritten in terms of the bound width (area = Lj*W, perimeter = 2*W + c; Lj and c from the netlist)
//   - mdvccta_fig2_A1.M25: junction geometry as/ad/ps/pd rewritten in terms of the bound width (area = Lj*W, perimeter = 2*W + c; Lj and c from the netlist)
//   - mdvccta_fig2_A1.M18: junction geometry as/ad/ps/pd rewritten in terms of the bound width (area = Lj*W, perimeter = 2*W + c; Lj and c from the netlist)
//   - mdvccta_fig2_A1.M17: junction geometry as/ad/ps/pd rewritten in terms of the bound width (area = Lj*W, perimeter = 2*W + c; Lj and c from the netlist)
//   - mdvccta_fig2_A1.M16: junction geometry as/ad/ps/pd rewritten in terms of the bound width (area = Lj*W, perimeter = 2*W + c; Lj and c from the netlist)
//   - mdvccta_fig2_A1.M15: junction geometry as/ad/ps/pd rewritten in terms of the bound width (area = Lj*W, perimeter = 2*W + c; Lj and c from the netlist)
//   - mdvccta_fig2_A1.M14: junction geometry as/ad/ps/pd rewritten in terms of the bound width (area = Lj*W, perimeter = 2*W + c; Lj and c from the netlist)
//   - mdvccta_fig2_A1.M13: junction geometry as/ad/ps/pd rewritten in terms of the bound width (area = Lj*W, perimeter = 2*W + c; Lj and c from the netlist)
//   - mdvccta_fig2_A1.M12: junction geometry as/ad/ps/pd rewritten in terms of the bound width (area = Lj*W, perimeter = 2*W + c; Lj and c from the netlist)
//   - mdvccta_fig2_A1.M11: junction geometry as/ad/ps/pd rewritten in terms of the bound width (area = Lj*W, perimeter = 2*W + c; Lj and c from the netlist)
//   - mdvccta_fig2_A1.M10: junction geometry as/ad/ps/pd rewritten in terms of the bound width (area = Lj*W, perimeter = 2*W + c; Lj and c from the netlist)
//   - mdvccta_fig2_A1.M2: junction geometry as/ad/ps/pd rewritten in terms of the bound width (area = Lj*W, perimeter = 2*W + c; Lj and c from the netlist)
//   - mdvccta_fig2_A1.M1: junction geometry as/ad/ps/pd rewritten in terms of the bound width (area = Lj*W, perimeter = 2*W + c; Lj and c from the netlist)
//   - mdvccta_fig2_A1.M24: junction geometry as/ad/ps/pd rewritten in terms of the bound width (area = Lj*W, perimeter = 2*W + c; Lj and c from the netlist)
//   - mdvccta_fig2_A1.M23: junction geometry as/ad/ps/pd rewritten in terms of the bound width (area = Lj*W, perimeter = 2*W + c; Lj and c from the netlist)
//   - mdvccta_fig2_A1.M22: junction geometry as/ad/ps/pd rewritten in terms of the bound width (area = Lj*W, perimeter = 2*W + c; Lj and c from the netlist)
//   - mdvccta_fig2_A1.M21: junction geometry as/ad/ps/pd rewritten in terms of the bound width (area = Lj*W, perimeter = 2*W + c; Lj and c from the netlist)
//   - mdvccta_fig2_A1.M20: junction geometry as/ad/ps/pd rewritten in terms of the bound width (area = Lj*W, perimeter = 2*W + c; Lj and c from the netlist)
//   - mdvccta_fig2_A1.M19: junction geometry as/ad/ps/pd rewritten in terms of the bound width (area = Lj*W, perimeter = 2*W + c; Lj and c from the netlist)
//   - mdvccta_fig2_A1.M9: junction geometry as/ad/ps/pd rewritten in terms of the bound width (area = Lj*W, perimeter = 2*W + c; Lj and c from the netlist)
//   - mdvccta_fig2_A1.M8: junction geometry as/ad/ps/pd rewritten in terms of the bound width (area = Lj*W, perimeter = 2*W + c; Lj and c from the netlist)
//   - mdvccta_fig2_A1.M7: junction geometry as/ad/ps/pd rewritten in terms of the bound width (area = Lj*W, perimeter = 2*W + c; Lj and c from the netlist)
//   - mdvccta_fig2_A1.M6: junction geometry as/ad/ps/pd rewritten in terms of the bound width (area = Lj*W, perimeter = 2*W + c; Lj and c from the netlist)
//   - mdvccta_fig2_A1.M5: junction geometry as/ad/ps/pd rewritten in terms of the bound width (area = Lj*W, perimeter = 2*W + c; Lj and c from the netlist)
//   - mdvccta_fig2_A1.M4: junction geometry as/ad/ps/pd rewritten in terms of the bound width (area = Lj*W, perimeter = 2*W + c; Lj and c from the netlist)
//   - mdvccta_fig2_A1.M3: junction geometry as/ad/ps/pd rewritten in terms of the bound width (area = Lj*W, perimeter = 2*W + c; Lj and c from the netlist)
//   - grounded_resistor_fig8a.MR2: junction geometry as/ad/ps/pd rewritten in terms of the bound width (area = Lj*W, perimeter = 2*W + c; Lj and c from the netlist)
//   - grounded_resistor_fig8a.MR1: junction geometry as/ad/ps/pd rewritten in terms of the bound width (area = Lj*W, perimeter = 2*W + c; Lj and c from the netlist)
//   - grounded_resistor_fig8a_R2.MR2: junction geometry as/ad/ps/pd rewritten in terms of the bound width (area = Lj*W, perimeter = 2*W + c; Lj and c from the netlist)
//   - grounded_resistor_fig8a_R2.MR1: junction geometry as/ad/ps/pd rewritten in terms of the bound width (area = Lj*W, perimeter = 2*W + c; Lj and c from the netlist)
//   - sizing variables bound inside local subckts are subckt parameters passed from the DUT instance(s): mdvccta_fig2: ['A2_IBIAS', 'A2_L_IN', 'A2_L_NDIO', 'A2_L_NMIR', 'A2_L_PLD', 'A2_L_PMIR', 'A2_M_IN', 'A2_M_NDIO', 'A2_M_NMIR', 'A2_M_PLD', 'A2_M_PMIR', 'A2_W_IN', 'A2_W_NDIO', 'A2_W_NMIR', 'A2_W_PLD', 'A2_W_PMIR', 'FE_L_IN', 'FE_L_NOUT', 'FE_L_NTAIL', 'FE_L_PMIR', 'FE_L_POUT', 'FE_M_IN', 'FE_M_NOUT', 'FE_M_NTAIL', 'FE_M_PMIR', 'FE_M_POUT', 'FE_W_IN', 'FE_W_NOUT', 'FE_W_NTAIL', 'FE_W_PMIR', 'FE_W_POUT'], mdvccta_fig2_A1: ['A1_IBIAS', 'A1_L_IN', 'A1_L_NDIO', 'A1_L_NMIR', 'A1_L_PLD', 'A1_L_PMIR', 'A1_M_IN', 'A1_M_NDIO', 'A1_M_NMIR', 'A1_M_PLD', 'A1_M_PMIR', 'A1_W_IN', 'A1_W_NDIO', 'A1_W_NMIR', 'A1_W_PLD', 'A1_W_PMIR', 'FE_L_IN', 'FE_L_NOUT', 'FE_L_NTAIL', 'FE_L_PMIR', 'FE_L_POUT', 'FE_M_IN', 'FE_M_NOUT', 'FE_M_NTAIL', 'FE_M_PMIR', 'FE_M_POUT', 'FE_W_IN', 'FE_W_NOUT', 'FE_W_NTAIL', 'FE_W_PMIR', 'FE_W_POUT'], grounded_resistor_fig8a: ['R1_L', 'R1_M', 'R1_W'], grounded_resistor_fig8a_R2: ['R2_L', 'R2_M', 'R2_W']
//   - widths bound to sizing variables on fold-capable devices are folded symbolically into ceil(W/max) fingers of W/ceil(W/max) (per-device max [0.0001] m): grounded_resistor_fig8a.MR1, grounded_resistor_fig8a.MR2, grounded_resistor_fig8a_R2.MR1, grounded_resistor_fig8a_R2.MR2, mdvccta_fig2.M1, mdvccta_fig2.M10, mdvccta_fig2.M11, mdvccta_fig2.M12, mdvccta_fig2.M13, mdvccta_fig2.M14, mdvccta_fig2.M15, mdvccta_fig2.M16, mdvccta_fig2.M17, mdvccta_fig2.M18, mdvccta_fig2.M19, mdvccta_fig2.M2, mdvccta_fig2.M20, mdvccta_fig2.M21, mdvccta_fig2.M22, mdvccta_fig2.M23, mdvccta_fig2.M24, mdvccta_fig2.M25, mdvccta_fig2.M26, mdvccta_fig2.M27, mdvccta_fig2.M28, mdvccta_fig2.M29, mdvccta_fig2.M3, mdvccta_fig2.M30, mdvccta_fig2.M4, mdvccta_fig2.M5, mdvccta_fig2.M6, mdvccta_fig2.M7, mdvccta_fig2.M8, mdvccta_fig2.M9, mdvccta_fig2_A1.M1, mdvccta_fig2_A1.M10, mdvccta_fig2_A1.M11, mdvccta_fig2_A1.M12, mdvccta_fig2_A1.M13, mdvccta_fig2_A1.M14, mdvccta_fig2_A1.M15, mdvccta_fig2_A1.M16, mdvccta_fig2_A1.M17, mdvccta_fig2_A1.M18, mdvccta_fig2_A1.M19, mdvccta_fig2_A1.M2, mdvccta_fig2_A1.M20, mdvccta_fig2_A1.M21, mdvccta_fig2_A1.M22, mdvccta_fig2_A1.M23, mdvccta_fig2_A1.M24, mdvccta_fig2_A1.M25, mdvccta_fig2_A1.M26, mdvccta_fig2_A1.M27, mdvccta_fig2_A1.M28, mdvccta_fig2_A1.M29, mdvccta_fig2_A1.M3, mdvccta_fig2_A1.M30, mdvccta_fig2_A1.M4, mdvccta_fig2_A1.M5, mdvccta_fig2_A1.M6, mdvccta_fig2_A1.M7, mdvccta_fig2_A1.M8, mdvccta_fig2_A1.M9
subckt mdvccta_fig2 (GND N OM OP OP2 VBIAS VDD VSS X Y1 Y2 Z1P Z2P ZP)
  parameters A2_IBIAS=1e-05 A2_L_IN=1e-06 A2_L_NDIO=1e-06 A2_L_NMIR=1e-06 A2_L_PLD=1e-06 A2_L_PMIR=1e-06 A2_M_IN=1.0 A2_M_NDIO=1.0 A2_M_NMIR=1.0 A2_M_PLD=1.0 A2_M_PMIR=1.0 A2_W_IN=1e-06 A2_W_NDIO=1e-06 A2_W_NMIR=1e-06 A2_W_PLD=1e-06 A2_W_PMIR=1e-06 FE_L_IN=1e-06 FE_L_NOUT=1e-06 FE_L_NTAIL=1e-06 FE_L_PMIR=1e-06 FE_L_POUT=1e-06 FE_M_IN=1.0 FE_M_NOUT=1.0 FE_M_NTAIL=1.0 FE_M_PMIR=1.0 FE_M_POUT=1.0 FE_W_IN=1e-06 FE_W_NOUT=1e-06 FE_W_NTAIL=1e-06 FE_W_PMIR=1e-06 FE_W_POUT=1e-06
  M30 (Z2P VBIAS VSS VSS) nmos1 w=(FE_W_NOUT/ceil(FE_W_NOUT/0.0001-1e-9)) l=FE_L_NOUT as=(6e-07*((FE_W_NOUT/ceil(FE_W_NOUT/0.0001-1e-9)))) ad=(6e-07*((FE_W_NOUT/ceil(FE_W_NOUT/0.0001-1e-9)))) ps=max(2*((FE_W_NOUT/ceil(FE_W_NOUT/0.0001-1e-9)))+(1.2e-06),0) pd=max(2*((FE_W_NOUT/ceil(FE_W_NOUT/0.0001-1e-9)))+(1.2e-06),0) m=FE_M_NOUT*ceil(FE_W_NOUT/0.0001-1e-9)
  M29 (Z1P VBIAS VSS VSS) nmos1 w=(FE_W_NOUT/ceil(FE_W_NOUT/0.0001-1e-9)) l=FE_L_NOUT as=(6e-07*((FE_W_NOUT/ceil(FE_W_NOUT/0.0001-1e-9)))) ad=(6e-07*((FE_W_NOUT/ceil(FE_W_NOUT/0.0001-1e-9)))) ps=max(2*((FE_W_NOUT/ceil(FE_W_NOUT/0.0001-1e-9)))+(1.2e-06),0) pd=max(2*((FE_W_NOUT/ceil(FE_W_NOUT/0.0001-1e-9)))+(1.2e-06),0) m=FE_M_NOUT*ceil(FE_W_NOUT/0.0001-1e-9)
  M28 (ZP VBIAS VSS VSS) nmos1 w=(FE_W_NOUT/ceil(FE_W_NOUT/0.0001-1e-9)) l=FE_L_NOUT as=(6e-07*((FE_W_NOUT/ceil(FE_W_NOUT/0.0001-1e-9)))) ad=(6e-07*((FE_W_NOUT/ceil(FE_W_NOUT/0.0001-1e-9)))) ps=max(2*((FE_W_NOUT/ceil(FE_W_NOUT/0.0001-1e-9)))+(1.2e-06),0) pd=max(2*((FE_W_NOUT/ceil(FE_W_NOUT/0.0001-1e-9)))+(1.2e-06),0) m=FE_M_NOUT*ceil(FE_W_NOUT/0.0001-1e-9)
  M27 (X VBIAS VSS VSS) nmos1 w=(FE_W_NOUT/ceil(FE_W_NOUT/0.0001-1e-9)) l=FE_L_NOUT as=(6e-07*((FE_W_NOUT/ceil(FE_W_NOUT/0.0001-1e-9)))) ad=(6e-07*((FE_W_NOUT/ceil(FE_W_NOUT/0.0001-1e-9)))) ps=max(2*((FE_W_NOUT/ceil(FE_W_NOUT/0.0001-1e-9)))+(1.2e-06),0) pd=max(2*((FE_W_NOUT/ceil(FE_W_NOUT/0.0001-1e-9)))+(1.2e-06),0) m=FE_M_NOUT*ceil(FE_W_NOUT/0.0001-1e-9)
  M26 (T2 VBIAS VSS VSS) nmos1 w=(FE_W_NTAIL/ceil(FE_W_NTAIL/0.0001-1e-9)) l=FE_L_NTAIL as=(6.000000000004845e-07*((FE_W_NTAIL/ceil(FE_W_NTAIL/0.0001-1e-9)))) ad=(6.000000000004845e-07*((FE_W_NTAIL/ceil(FE_W_NTAIL/0.0001-1e-9)))) ps=max(2*((FE_W_NTAIL/ceil(FE_W_NTAIL/0.0001-1e-9)))+(1.1999999999899986e-06),0) pd=max(2*((FE_W_NTAIL/ceil(FE_W_NTAIL/0.0001-1e-9)))+(1.1999999999899986e-06),0) m=FE_M_NTAIL*ceil(FE_W_NTAIL/0.0001-1e-9)
  M25 (T1 VBIAS VSS VSS) nmos1 w=(FE_W_NTAIL/ceil(FE_W_NTAIL/0.0001-1e-9)) l=FE_L_NTAIL as=(6.000000000004845e-07*((FE_W_NTAIL/ceil(FE_W_NTAIL/0.0001-1e-9)))) ad=(6.000000000004845e-07*((FE_W_NTAIL/ceil(FE_W_NTAIL/0.0001-1e-9)))) ps=max(2*((FE_W_NTAIL/ceil(FE_W_NTAIL/0.0001-1e-9)))+(1.1999999999899986e-06),0) pd=max(2*((FE_W_NTAIL/ceil(FE_W_NTAIL/0.0001-1e-9)))+(1.1999999999899986e-06),0) m=FE_M_NTAIL*ceil(FE_W_NTAIL/0.0001-1e-9)
  M18 (NG Y1 T2 VSS) nmos1 w=(FE_W_IN/ceil(FE_W_IN/0.0001-1e-9)) l=FE_L_IN as=(5.99999999999036e-07*((FE_W_IN/ceil(FE_W_IN/0.0001-1e-9)))) ad=(5.99999999999036e-07*((FE_W_IN/ceil(FE_W_IN/0.0001-1e-9)))) ps=max(2*((FE_W_IN/ceil(FE_W_IN/0.0001-1e-9)))+(1.1999999999999987e-06),0) pd=max(2*((FE_W_IN/ceil(FE_W_IN/0.0001-1e-9)))+(1.1999999999999987e-06),0) m=FE_M_IN*ceil(FE_W_IN/0.0001-1e-9)
  M17 (PG X T2 VSS) nmos1 w=(FE_W_IN/ceil(FE_W_IN/0.0001-1e-9)) l=FE_L_IN as=(5.99999999999036e-07*((FE_W_IN/ceil(FE_W_IN/0.0001-1e-9)))) ad=(5.99999999999036e-07*((FE_W_IN/ceil(FE_W_IN/0.0001-1e-9)))) ps=max(2*((FE_W_IN/ceil(FE_W_IN/0.0001-1e-9)))+(1.1999999999999987e-06),0) pd=max(2*((FE_W_IN/ceil(FE_W_IN/0.0001-1e-9)))+(1.1999999999999987e-06),0) m=FE_M_IN*ceil(FE_W_IN/0.0001-1e-9)
  M16 (NG GND T1 VSS) nmos1 w=(FE_W_IN/ceil(FE_W_IN/0.0001-1e-9)) l=FE_L_IN as=(5.99999999999036e-07*((FE_W_IN/ceil(FE_W_IN/0.0001-1e-9)))) ad=(5.99999999999036e-07*((FE_W_IN/ceil(FE_W_IN/0.0001-1e-9)))) ps=max(2*((FE_W_IN/ceil(FE_W_IN/0.0001-1e-9)))+(1.1999999999999987e-06),0) pd=max(2*((FE_W_IN/ceil(FE_W_IN/0.0001-1e-9)))+(1.1999999999999987e-06),0) m=FE_M_IN*ceil(FE_W_IN/0.0001-1e-9)
  M15 (PG Y2 T1 VSS) nmos1 w=(FE_W_IN/ceil(FE_W_IN/0.0001-1e-9)) l=FE_L_IN as=(5.99999999999036e-07*((FE_W_IN/ceil(FE_W_IN/0.0001-1e-9)))) ad=(5.99999999999036e-07*((FE_W_IN/ceil(FE_W_IN/0.0001-1e-9)))) ps=max(2*((FE_W_IN/ceil(FE_W_IN/0.0001-1e-9)))+(1.1999999999999987e-06),0) pd=max(2*((FE_W_IN/ceil(FE_W_IN/0.0001-1e-9)))+(1.1999999999999987e-06),0) m=FE_M_IN*ceil(FE_W_IN/0.0001-1e-9)
  M14 (PB PB VSS VSS) nmos1 w=(A2_W_NDIO/ceil(A2_W_NDIO/0.0001-1e-9)) l=A2_L_NDIO as=(6e-07*((A2_W_NDIO/ceil(A2_W_NDIO/0.0001-1e-9)))) ad=(6e-07*((A2_W_NDIO/ceil(A2_W_NDIO/0.0001-1e-9)))) ps=max(2*((A2_W_NDIO/ceil(A2_W_NDIO/0.0001-1e-9)))+(1.1999999999999997e-06),0) pd=max(2*((A2_W_NDIO/ceil(A2_W_NDIO/0.0001-1e-9)))+(1.1999999999999997e-06),0) m=A2_M_NDIO*ceil(A2_W_NDIO/0.0001-1e-9)
  M13 (OP2 NB VSS VSS) nmos1 w=(A2_W_NMIR/ceil(A2_W_NMIR/0.0001-1e-9)) l=A2_L_NMIR as=(6.000000000005024e-07*((A2_W_NMIR/ceil(A2_W_NMIR/0.0001-1e-9)))) ad=(6.000000000005024e-07*((A2_W_NMIR/ceil(A2_W_NMIR/0.0001-1e-9)))) ps=max(2*((A2_W_NMIR/ceil(A2_W_NMIR/0.0001-1e-9)))+(1.2000000000099987e-06),0) pd=max(2*((A2_W_NMIR/ceil(A2_W_NMIR/0.0001-1e-9)))+(1.2000000000099987e-06),0) m=A2_M_NMIR*ceil(A2_W_NMIR/0.0001-1e-9)
  M12 (OP NB VSS VSS) nmos1 w=(A2_W_NMIR/ceil(A2_W_NMIR/0.0001-1e-9)) l=A2_L_NMIR as=(6.000000000005024e-07*((A2_W_NMIR/ceil(A2_W_NMIR/0.0001-1e-9)))) ad=(6.000000000005024e-07*((A2_W_NMIR/ceil(A2_W_NMIR/0.0001-1e-9)))) ps=max(2*((A2_W_NMIR/ceil(A2_W_NMIR/0.0001-1e-9)))+(1.2000000000099987e-06),0) pd=max(2*((A2_W_NMIR/ceil(A2_W_NMIR/0.0001-1e-9)))+(1.2000000000099987e-06),0) m=A2_M_NMIR*ceil(A2_W_NMIR/0.0001-1e-9)
  M11 (NB NB VSS VSS) nmos1 w=(A2_W_NDIO/ceil(A2_W_NDIO/0.0001-1e-9)) l=A2_L_NDIO as=(6e-07*((A2_W_NDIO/ceil(A2_W_NDIO/0.0001-1e-9)))) ad=(6e-07*((A2_W_NDIO/ceil(A2_W_NDIO/0.0001-1e-9)))) ps=max(2*((A2_W_NDIO/ceil(A2_W_NDIO/0.0001-1e-9)))+(1.1999999999999997e-06),0) pd=max(2*((A2_W_NDIO/ceil(A2_W_NDIO/0.0001-1e-9)))+(1.1999999999999997e-06),0) m=A2_M_NDIO*ceil(A2_W_NDIO/0.0001-1e-9)
  M10 (OM PB VSS VSS) nmos1 w=(A2_W_NMIR/ceil(A2_W_NMIR/0.0001-1e-9)) l=A2_L_NMIR as=(6.000000000005024e-07*((A2_W_NMIR/ceil(A2_W_NMIR/0.0001-1e-9)))) ad=(6.000000000005024e-07*((A2_W_NMIR/ceil(A2_W_NMIR/0.0001-1e-9)))) ps=max(2*((A2_W_NMIR/ceil(A2_W_NMIR/0.0001-1e-9)))+(1.2000000000099987e-06),0) pd=max(2*((A2_W_NMIR/ceil(A2_W_NMIR/0.0001-1e-9)))+(1.2000000000099987e-06),0) m=A2_M_NMIR*ceil(A2_W_NMIR/0.0001-1e-9)
  M2 (NR ZP T VSS) nmos1 w=(A2_W_IN/ceil(A2_W_IN/0.0001-1e-9)) l=A2_L_IN as=(6e-07*((A2_W_IN/ceil(A2_W_IN/0.0001-1e-9)))) ad=(6e-07*((A2_W_IN/ceil(A2_W_IN/0.0001-1e-9)))) ps=max(2*((A2_W_IN/ceil(A2_W_IN/0.0001-1e-9)))+(1.200000000000002e-06),0) pd=max(2*((A2_W_IN/ceil(A2_W_IN/0.0001-1e-9)))+(1.200000000000002e-06),0) m=A2_M_IN*ceil(A2_W_IN/0.0001-1e-9)
  M1 (NL N T VSS) nmos1 w=(A2_W_IN/ceil(A2_W_IN/0.0001-1e-9)) l=A2_L_IN as=(6e-07*((A2_W_IN/ceil(A2_W_IN/0.0001-1e-9)))) ad=(6e-07*((A2_W_IN/ceil(A2_W_IN/0.0001-1e-9)))) ps=max(2*((A2_W_IN/ceil(A2_W_IN/0.0001-1e-9)))+(1.200000000000002e-06),0) pd=max(2*((A2_W_IN/ceil(A2_W_IN/0.0001-1e-9)))+(1.200000000000002e-06),0) m=A2_M_IN*ceil(A2_W_IN/0.0001-1e-9)
  M24 (Z2P NG VDD VDD) pmos1 w=(FE_W_POUT/ceil(FE_W_POUT/0.0001-1e-9)) l=FE_L_POUT as=(5.999999999996845e-07*((FE_W_POUT/ceil(FE_W_POUT/0.0001-1e-9)))) ad=(5.999999999996845e-07*((FE_W_POUT/ceil(FE_W_POUT/0.0001-1e-9)))) ps=max(2*((FE_W_POUT/ceil(FE_W_POUT/0.0001-1e-9)))+(1.2000000000600008e-06),0) pd=max(2*((FE_W_POUT/ceil(FE_W_POUT/0.0001-1e-9)))+(1.2000000000600008e-06),0) m=FE_M_POUT*ceil(FE_W_POUT/0.0001-1e-9)
  M23 (Z1P NG VDD VDD) pmos1 w=(FE_W_POUT/ceil(FE_W_POUT/0.0001-1e-9)) l=FE_L_POUT as=(5.999999999996845e-07*((FE_W_POUT/ceil(FE_W_POUT/0.0001-1e-9)))) ad=(5.999999999996845e-07*((FE_W_POUT/ceil(FE_W_POUT/0.0001-1e-9)))) ps=max(2*((FE_W_POUT/ceil(FE_W_POUT/0.0001-1e-9)))+(1.2000000000600008e-06),0) pd=max(2*((FE_W_POUT/ceil(FE_W_POUT/0.0001-1e-9)))+(1.2000000000600008e-06),0) m=FE_M_POUT*ceil(FE_W_POUT/0.0001-1e-9)
  M22 (ZP NG VDD VDD) pmos1 w=(FE_W_POUT/ceil(FE_W_POUT/0.0001-1e-9)) l=FE_L_POUT as=(5.999999999996845e-07*((FE_W_POUT/ceil(FE_W_POUT/0.0001-1e-9)))) ad=(5.999999999996845e-07*((FE_W_POUT/ceil(FE_W_POUT/0.0001-1e-9)))) ps=max(2*((FE_W_POUT/ceil(FE_W_POUT/0.0001-1e-9)))+(1.2000000000600008e-06),0) pd=max(2*((FE_W_POUT/ceil(FE_W_POUT/0.0001-1e-9)))+(1.2000000000600008e-06),0) m=FE_M_POUT*ceil(FE_W_POUT/0.0001-1e-9)
  M21 (X NG VDD VDD) pmos1 w=(FE_W_POUT/ceil(FE_W_POUT/0.0001-1e-9)) l=FE_L_POUT as=(5.999999999996845e-07*((FE_W_POUT/ceil(FE_W_POUT/0.0001-1e-9)))) ad=(5.999999999996845e-07*((FE_W_POUT/ceil(FE_W_POUT/0.0001-1e-9)))) ps=max(2*((FE_W_POUT/ceil(FE_W_POUT/0.0001-1e-9)))+(1.2000000000600008e-06),0) pd=max(2*((FE_W_POUT/ceil(FE_W_POUT/0.0001-1e-9)))+(1.2000000000600008e-06),0) m=FE_M_POUT*ceil(FE_W_POUT/0.0001-1e-9)
  M20 (NG PG VDD VDD) pmos1 w=(FE_W_PMIR/ceil(FE_W_PMIR/0.0001-1e-9)) l=FE_L_PMIR as=(6.000000000016381e-07*((FE_W_PMIR/ceil(FE_W_PMIR/0.0001-1e-9)))) ad=(6.000000000016381e-07*((FE_W_PMIR/ceil(FE_W_PMIR/0.0001-1e-9)))) ps=max(2*((FE_W_PMIR/ceil(FE_W_PMIR/0.0001-1e-9)))+(1.199999999980002e-06),0) pd=max(2*((FE_W_PMIR/ceil(FE_W_PMIR/0.0001-1e-9)))+(1.199999999980002e-06),0) m=FE_M_PMIR*ceil(FE_W_PMIR/0.0001-1e-9)
  M19 (PG PG VDD VDD) pmos1 w=(FE_W_PMIR/ceil(FE_W_PMIR/0.0001-1e-9)) l=FE_L_PMIR as=(6.000000000016381e-07*((FE_W_PMIR/ceil(FE_W_PMIR/0.0001-1e-9)))) ad=(6.000000000016381e-07*((FE_W_PMIR/ceil(FE_W_PMIR/0.0001-1e-9)))) ps=max(2*((FE_W_PMIR/ceil(FE_W_PMIR/0.0001-1e-9)))+(1.199999999980002e-06),0) pd=max(2*((FE_W_PMIR/ceil(FE_W_PMIR/0.0001-1e-9)))+(1.199999999980002e-06),0) m=FE_M_PMIR*ceil(FE_W_PMIR/0.0001-1e-9)
  M9 (PB NR VDD VDD) pmos1 w=(A2_W_PMIR/ceil(A2_W_PMIR/0.0001-1e-9)) l=A2_L_PMIR as=(6.000000000021237e-07*((A2_W_PMIR/ceil(A2_W_PMIR/0.0001-1e-9)))) ad=(6.000000000021237e-07*((A2_W_PMIR/ceil(A2_W_PMIR/0.0001-1e-9)))) ps=max(2*((A2_W_PMIR/ceil(A2_W_PMIR/0.0001-1e-9)))+(1.2000000000999994e-06),0) pd=max(2*((A2_W_PMIR/ceil(A2_W_PMIR/0.0001-1e-9)))+(1.2000000000999994e-06),0) m=A2_M_PMIR*ceil(A2_W_PMIR/0.0001-1e-9)
  M8 (OP2 NR VDD VDD) pmos1 w=(A2_W_PMIR/ceil(A2_W_PMIR/0.0001-1e-9)) l=A2_L_PMIR as=(6.000000000021237e-07*((A2_W_PMIR/ceil(A2_W_PMIR/0.0001-1e-9)))) ad=(6.000000000021237e-07*((A2_W_PMIR/ceil(A2_W_PMIR/0.0001-1e-9)))) ps=max(2*((A2_W_PMIR/ceil(A2_W_PMIR/0.0001-1e-9)))+(1.2000000000999994e-06),0) pd=max(2*((A2_W_PMIR/ceil(A2_W_PMIR/0.0001-1e-9)))+(1.2000000000999994e-06),0) m=A2_M_PMIR*ceil(A2_W_PMIR/0.0001-1e-9)
  M7 (OP NR VDD VDD) pmos1 w=(A2_W_PMIR/ceil(A2_W_PMIR/0.0001-1e-9)) l=A2_L_PMIR as=(6.000000000021237e-07*((A2_W_PMIR/ceil(A2_W_PMIR/0.0001-1e-9)))) ad=(6.000000000021237e-07*((A2_W_PMIR/ceil(A2_W_PMIR/0.0001-1e-9)))) ps=max(2*((A2_W_PMIR/ceil(A2_W_PMIR/0.0001-1e-9)))+(1.2000000000999994e-06),0) pd=max(2*((A2_W_PMIR/ceil(A2_W_PMIR/0.0001-1e-9)))+(1.2000000000999994e-06),0) m=A2_M_PMIR*ceil(A2_W_PMIR/0.0001-1e-9)
  M6 (NR NR VDD VDD) pmos1 w=(A2_W_PLD/ceil(A2_W_PLD/0.0001-1e-9)) l=A2_L_PLD as=(5.999999999980462e-07*((A2_W_PLD/ceil(A2_W_PLD/0.0001-1e-9)))) ad=(5.999999999980462e-07*((A2_W_PLD/ceil(A2_W_PLD/0.0001-1e-9)))) ps=max(2*((A2_W_PLD/ceil(A2_W_PLD/0.0001-1e-9)))+(1.19999999996e-06),0) pd=max(2*((A2_W_PLD/ceil(A2_W_PLD/0.0001-1e-9)))+(1.19999999996e-06),0) m=A2_M_PLD*ceil(A2_W_PLD/0.0001-1e-9)
  M5 (NL NL VDD VDD) pmos1 w=(A2_W_PLD/ceil(A2_W_PLD/0.0001-1e-9)) l=A2_L_PLD as=(5.999999999980462e-07*((A2_W_PLD/ceil(A2_W_PLD/0.0001-1e-9)))) ad=(5.999999999980462e-07*((A2_W_PLD/ceil(A2_W_PLD/0.0001-1e-9)))) ps=max(2*((A2_W_PLD/ceil(A2_W_PLD/0.0001-1e-9)))+(1.19999999996e-06),0) pd=max(2*((A2_W_PLD/ceil(A2_W_PLD/0.0001-1e-9)))+(1.19999999996e-06),0) m=A2_M_PLD*ceil(A2_W_PLD/0.0001-1e-9)
  M4 (NB NL VDD VDD) pmos1 w=(A2_W_PMIR/ceil(A2_W_PMIR/0.0001-1e-9)) l=A2_L_PMIR as=(6.000000000021237e-07*((A2_W_PMIR/ceil(A2_W_PMIR/0.0001-1e-9)))) ad=(6.000000000021237e-07*((A2_W_PMIR/ceil(A2_W_PMIR/0.0001-1e-9)))) ps=max(2*((A2_W_PMIR/ceil(A2_W_PMIR/0.0001-1e-9)))+(1.2000000000999994e-06),0) pd=max(2*((A2_W_PMIR/ceil(A2_W_PMIR/0.0001-1e-9)))+(1.2000000000999994e-06),0) m=A2_M_PMIR*ceil(A2_W_PMIR/0.0001-1e-9)
  M3 (OM NL VDD VDD) pmos1 w=(A2_W_PMIR/ceil(A2_W_PMIR/0.0001-1e-9)) l=A2_L_PMIR as=(6.000000000021237e-07*((A2_W_PMIR/ceil(A2_W_PMIR/0.0001-1e-9)))) ad=(6.000000000021237e-07*((A2_W_PMIR/ceil(A2_W_PMIR/0.0001-1e-9)))) ps=max(2*((A2_W_PMIR/ceil(A2_W_PMIR/0.0001-1e-9)))+(1.2000000000999994e-06),0) pd=max(2*((A2_W_PMIR/ceil(A2_W_PMIR/0.0001-1e-9)))+(1.2000000000999994e-06),0) m=A2_M_PMIR*ceil(A2_W_PMIR/0.0001-1e-9)
  IBIAS (T VSS) isource dc=A2_IBIAS type=dc
ends mdvccta_fig2
subckt mdvccta_fig2_A1 (GND N OM OP OP2 VBIAS VDD VSS X Y1 Y2 Z1P Z2P ZP)
  parameters A1_IBIAS=1e-05 A1_L_IN=1e-06 A1_L_NDIO=1e-06 A1_L_NMIR=1e-06 A1_L_PLD=1e-06 A1_L_PMIR=1e-06 A1_M_IN=1.0 A1_M_NDIO=1.0 A1_M_NMIR=1.0 A1_M_PLD=1.0 A1_M_PMIR=1.0 A1_W_IN=1e-06 A1_W_NDIO=1e-06 A1_W_NMIR=1e-06 A1_W_PLD=1e-06 A1_W_PMIR=1e-06 FE_L_IN=1e-06 FE_L_NOUT=1e-06 FE_L_NTAIL=1e-06 FE_L_PMIR=1e-06 FE_L_POUT=1e-06 FE_M_IN=1.0 FE_M_NOUT=1.0 FE_M_NTAIL=1.0 FE_M_PMIR=1.0 FE_M_POUT=1.0 FE_W_IN=1e-06 FE_W_NOUT=1e-06 FE_W_NTAIL=1e-06 FE_W_PMIR=1e-06 FE_W_POUT=1e-06
  M30 (Z2P VBIAS VSS VSS) nmos1 w=(FE_W_NOUT/ceil(FE_W_NOUT/0.0001-1e-9)) l=FE_L_NOUT as=(6e-07*((FE_W_NOUT/ceil(FE_W_NOUT/0.0001-1e-9)))) ad=(6e-07*((FE_W_NOUT/ceil(FE_W_NOUT/0.0001-1e-9)))) ps=max(2*((FE_W_NOUT/ceil(FE_W_NOUT/0.0001-1e-9)))+(1.2e-06),0) pd=max(2*((FE_W_NOUT/ceil(FE_W_NOUT/0.0001-1e-9)))+(1.2e-06),0) m=FE_M_NOUT*ceil(FE_W_NOUT/0.0001-1e-9)
  M29 (Z1P VBIAS VSS VSS) nmos1 w=(FE_W_NOUT/ceil(FE_W_NOUT/0.0001-1e-9)) l=FE_L_NOUT as=(6e-07*((FE_W_NOUT/ceil(FE_W_NOUT/0.0001-1e-9)))) ad=(6e-07*((FE_W_NOUT/ceil(FE_W_NOUT/0.0001-1e-9)))) ps=max(2*((FE_W_NOUT/ceil(FE_W_NOUT/0.0001-1e-9)))+(1.2e-06),0) pd=max(2*((FE_W_NOUT/ceil(FE_W_NOUT/0.0001-1e-9)))+(1.2e-06),0) m=FE_M_NOUT*ceil(FE_W_NOUT/0.0001-1e-9)
  M28 (ZP VBIAS VSS VSS) nmos1 w=(FE_W_NOUT/ceil(FE_W_NOUT/0.0001-1e-9)) l=FE_L_NOUT as=(6e-07*((FE_W_NOUT/ceil(FE_W_NOUT/0.0001-1e-9)))) ad=(6e-07*((FE_W_NOUT/ceil(FE_W_NOUT/0.0001-1e-9)))) ps=max(2*((FE_W_NOUT/ceil(FE_W_NOUT/0.0001-1e-9)))+(1.2e-06),0) pd=max(2*((FE_W_NOUT/ceil(FE_W_NOUT/0.0001-1e-9)))+(1.2e-06),0) m=FE_M_NOUT*ceil(FE_W_NOUT/0.0001-1e-9)
  M27 (X VBIAS VSS VSS) nmos1 w=(FE_W_NOUT/ceil(FE_W_NOUT/0.0001-1e-9)) l=FE_L_NOUT as=(6e-07*((FE_W_NOUT/ceil(FE_W_NOUT/0.0001-1e-9)))) ad=(6e-07*((FE_W_NOUT/ceil(FE_W_NOUT/0.0001-1e-9)))) ps=max(2*((FE_W_NOUT/ceil(FE_W_NOUT/0.0001-1e-9)))+(1.2e-06),0) pd=max(2*((FE_W_NOUT/ceil(FE_W_NOUT/0.0001-1e-9)))+(1.2e-06),0) m=FE_M_NOUT*ceil(FE_W_NOUT/0.0001-1e-9)
  M26 (T2 VBIAS VSS VSS) nmos1 w=(FE_W_NTAIL/ceil(FE_W_NTAIL/0.0001-1e-9)) l=FE_L_NTAIL as=(6.000000000004845e-07*((FE_W_NTAIL/ceil(FE_W_NTAIL/0.0001-1e-9)))) ad=(6.000000000004845e-07*((FE_W_NTAIL/ceil(FE_W_NTAIL/0.0001-1e-9)))) ps=max(2*((FE_W_NTAIL/ceil(FE_W_NTAIL/0.0001-1e-9)))+(1.1999999999899986e-06),0) pd=max(2*((FE_W_NTAIL/ceil(FE_W_NTAIL/0.0001-1e-9)))+(1.1999999999899986e-06),0) m=FE_M_NTAIL*ceil(FE_W_NTAIL/0.0001-1e-9)
  M25 (T1 VBIAS VSS VSS) nmos1 w=(FE_W_NTAIL/ceil(FE_W_NTAIL/0.0001-1e-9)) l=FE_L_NTAIL as=(6.000000000004845e-07*((FE_W_NTAIL/ceil(FE_W_NTAIL/0.0001-1e-9)))) ad=(6.000000000004845e-07*((FE_W_NTAIL/ceil(FE_W_NTAIL/0.0001-1e-9)))) ps=max(2*((FE_W_NTAIL/ceil(FE_W_NTAIL/0.0001-1e-9)))+(1.1999999999899986e-06),0) pd=max(2*((FE_W_NTAIL/ceil(FE_W_NTAIL/0.0001-1e-9)))+(1.1999999999899986e-06),0) m=FE_M_NTAIL*ceil(FE_W_NTAIL/0.0001-1e-9)
  M18 (NG Y1 T2 VSS) nmos1 w=(FE_W_IN/ceil(FE_W_IN/0.0001-1e-9)) l=FE_L_IN as=(5.99999999999036e-07*((FE_W_IN/ceil(FE_W_IN/0.0001-1e-9)))) ad=(5.99999999999036e-07*((FE_W_IN/ceil(FE_W_IN/0.0001-1e-9)))) ps=max(2*((FE_W_IN/ceil(FE_W_IN/0.0001-1e-9)))+(1.1999999999999987e-06),0) pd=max(2*((FE_W_IN/ceil(FE_W_IN/0.0001-1e-9)))+(1.1999999999999987e-06),0) m=FE_M_IN*ceil(FE_W_IN/0.0001-1e-9)
  M17 (PG X T2 VSS) nmos1 w=(FE_W_IN/ceil(FE_W_IN/0.0001-1e-9)) l=FE_L_IN as=(5.99999999999036e-07*((FE_W_IN/ceil(FE_W_IN/0.0001-1e-9)))) ad=(5.99999999999036e-07*((FE_W_IN/ceil(FE_W_IN/0.0001-1e-9)))) ps=max(2*((FE_W_IN/ceil(FE_W_IN/0.0001-1e-9)))+(1.1999999999999987e-06),0) pd=max(2*((FE_W_IN/ceil(FE_W_IN/0.0001-1e-9)))+(1.1999999999999987e-06),0) m=FE_M_IN*ceil(FE_W_IN/0.0001-1e-9)
  M16 (NG GND T1 VSS) nmos1 w=(FE_W_IN/ceil(FE_W_IN/0.0001-1e-9)) l=FE_L_IN as=(5.99999999999036e-07*((FE_W_IN/ceil(FE_W_IN/0.0001-1e-9)))) ad=(5.99999999999036e-07*((FE_W_IN/ceil(FE_W_IN/0.0001-1e-9)))) ps=max(2*((FE_W_IN/ceil(FE_W_IN/0.0001-1e-9)))+(1.1999999999999987e-06),0) pd=max(2*((FE_W_IN/ceil(FE_W_IN/0.0001-1e-9)))+(1.1999999999999987e-06),0) m=FE_M_IN*ceil(FE_W_IN/0.0001-1e-9)
  M15 (PG Y2 T1 VSS) nmos1 w=(FE_W_IN/ceil(FE_W_IN/0.0001-1e-9)) l=FE_L_IN as=(5.99999999999036e-07*((FE_W_IN/ceil(FE_W_IN/0.0001-1e-9)))) ad=(5.99999999999036e-07*((FE_W_IN/ceil(FE_W_IN/0.0001-1e-9)))) ps=max(2*((FE_W_IN/ceil(FE_W_IN/0.0001-1e-9)))+(1.1999999999999987e-06),0) pd=max(2*((FE_W_IN/ceil(FE_W_IN/0.0001-1e-9)))+(1.1999999999999987e-06),0) m=FE_M_IN*ceil(FE_W_IN/0.0001-1e-9)
  M14 (PB PB VSS VSS) nmos1 w=(A1_W_NDIO/ceil(A1_W_NDIO/0.0001-1e-9)) l=A1_L_NDIO as=(5.999999999991066e-07*((A1_W_NDIO/ceil(A1_W_NDIO/0.0001-1e-9)))) ad=(5.999999999991066e-07*((A1_W_NDIO/ceil(A1_W_NDIO/0.0001-1e-9)))) ps=max(2*((A1_W_NDIO/ceil(A1_W_NDIO/0.0001-1e-9)))+(1.2000000000199988e-06),0) pd=max(2*((A1_W_NDIO/ceil(A1_W_NDIO/0.0001-1e-9)))+(1.2000000000199988e-06),0) m=A1_M_NDIO*ceil(A1_W_NDIO/0.0001-1e-9)
  M13 (OP2 NB VSS VSS) nmos1 w=(A1_W_NMIR/ceil(A1_W_NMIR/0.0001-1e-9)) l=A1_L_NMIR as=(5.999999999991066e-07*((A1_W_NMIR/ceil(A1_W_NMIR/0.0001-1e-9)))) ad=(5.999999999991066e-07*((A1_W_NMIR/ceil(A1_W_NMIR/0.0001-1e-9)))) ps=max(2*((A1_W_NMIR/ceil(A1_W_NMIR/0.0001-1e-9)))+(1.2000000000199988e-06),0) pd=max(2*((A1_W_NMIR/ceil(A1_W_NMIR/0.0001-1e-9)))+(1.2000000000199988e-06),0) m=A1_M_NMIR*ceil(A1_W_NMIR/0.0001-1e-9)
  M12 (OP NB VSS VSS) nmos1 w=(A1_W_NMIR/ceil(A1_W_NMIR/0.0001-1e-9)) l=A1_L_NMIR as=(5.999999999991066e-07*((A1_W_NMIR/ceil(A1_W_NMIR/0.0001-1e-9)))) ad=(5.999999999991066e-07*((A1_W_NMIR/ceil(A1_W_NMIR/0.0001-1e-9)))) ps=max(2*((A1_W_NMIR/ceil(A1_W_NMIR/0.0001-1e-9)))+(1.2000000000199988e-06),0) pd=max(2*((A1_W_NMIR/ceil(A1_W_NMIR/0.0001-1e-9)))+(1.2000000000199988e-06),0) m=A1_M_NMIR*ceil(A1_W_NMIR/0.0001-1e-9)
  M11 (NB NB VSS VSS) nmos1 w=(A1_W_NDIO/ceil(A1_W_NDIO/0.0001-1e-9)) l=A1_L_NDIO as=(5.999999999991066e-07*((A1_W_NDIO/ceil(A1_W_NDIO/0.0001-1e-9)))) ad=(5.999999999991066e-07*((A1_W_NDIO/ceil(A1_W_NDIO/0.0001-1e-9)))) ps=max(2*((A1_W_NDIO/ceil(A1_W_NDIO/0.0001-1e-9)))+(1.2000000000199988e-06),0) pd=max(2*((A1_W_NDIO/ceil(A1_W_NDIO/0.0001-1e-9)))+(1.2000000000199988e-06),0) m=A1_M_NDIO*ceil(A1_W_NDIO/0.0001-1e-9)
  M10 (OM PB VSS VSS) nmos1 w=(A1_W_NMIR/ceil(A1_W_NMIR/0.0001-1e-9)) l=A1_L_NMIR as=(5.999999999991066e-07*((A1_W_NMIR/ceil(A1_W_NMIR/0.0001-1e-9)))) ad=(5.999999999991066e-07*((A1_W_NMIR/ceil(A1_W_NMIR/0.0001-1e-9)))) ps=max(2*((A1_W_NMIR/ceil(A1_W_NMIR/0.0001-1e-9)))+(1.2000000000199988e-06),0) pd=max(2*((A1_W_NMIR/ceil(A1_W_NMIR/0.0001-1e-9)))+(1.2000000000199988e-06),0) m=A1_M_NMIR*ceil(A1_W_NMIR/0.0001-1e-9)
  M2 (NR ZP T VSS) nmos1 w=(A1_W_IN/ceil(A1_W_IN/0.0001-1e-9)) l=A1_L_IN as=(6e-07*((A1_W_IN/ceil(A1_W_IN/0.0001-1e-9)))) ad=(6e-07*((A1_W_IN/ceil(A1_W_IN/0.0001-1e-9)))) ps=max(2*((A1_W_IN/ceil(A1_W_IN/0.0001-1e-9)))+(1.200000000000002e-06),0) pd=max(2*((A1_W_IN/ceil(A1_W_IN/0.0001-1e-9)))+(1.200000000000002e-06),0) m=A1_M_IN*ceil(A1_W_IN/0.0001-1e-9)
  M1 (NL N T VSS) nmos1 w=(A1_W_IN/ceil(A1_W_IN/0.0001-1e-9)) l=A1_L_IN as=(6e-07*((A1_W_IN/ceil(A1_W_IN/0.0001-1e-9)))) ad=(6e-07*((A1_W_IN/ceil(A1_W_IN/0.0001-1e-9)))) ps=max(2*((A1_W_IN/ceil(A1_W_IN/0.0001-1e-9)))+(1.200000000000002e-06),0) pd=max(2*((A1_W_IN/ceil(A1_W_IN/0.0001-1e-9)))+(1.200000000000002e-06),0) m=A1_M_IN*ceil(A1_W_IN/0.0001-1e-9)
  M24 (Z2P NG VDD VDD) pmos1 w=(FE_W_POUT/ceil(FE_W_POUT/0.0001-1e-9)) l=FE_L_POUT as=(5.999999999996845e-07*((FE_W_POUT/ceil(FE_W_POUT/0.0001-1e-9)))) ad=(5.999999999996845e-07*((FE_W_POUT/ceil(FE_W_POUT/0.0001-1e-9)))) ps=max(2*((FE_W_POUT/ceil(FE_W_POUT/0.0001-1e-9)))+(1.2000000000600008e-06),0) pd=max(2*((FE_W_POUT/ceil(FE_W_POUT/0.0001-1e-9)))+(1.2000000000600008e-06),0) m=FE_M_POUT*ceil(FE_W_POUT/0.0001-1e-9)
  M23 (Z1P NG VDD VDD) pmos1 w=(FE_W_POUT/ceil(FE_W_POUT/0.0001-1e-9)) l=FE_L_POUT as=(5.999999999996845e-07*((FE_W_POUT/ceil(FE_W_POUT/0.0001-1e-9)))) ad=(5.999999999996845e-07*((FE_W_POUT/ceil(FE_W_POUT/0.0001-1e-9)))) ps=max(2*((FE_W_POUT/ceil(FE_W_POUT/0.0001-1e-9)))+(1.2000000000600008e-06),0) pd=max(2*((FE_W_POUT/ceil(FE_W_POUT/0.0001-1e-9)))+(1.2000000000600008e-06),0) m=FE_M_POUT*ceil(FE_W_POUT/0.0001-1e-9)
  M22 (ZP NG VDD VDD) pmos1 w=(FE_W_POUT/ceil(FE_W_POUT/0.0001-1e-9)) l=FE_L_POUT as=(5.999999999996845e-07*((FE_W_POUT/ceil(FE_W_POUT/0.0001-1e-9)))) ad=(5.999999999996845e-07*((FE_W_POUT/ceil(FE_W_POUT/0.0001-1e-9)))) ps=max(2*((FE_W_POUT/ceil(FE_W_POUT/0.0001-1e-9)))+(1.2000000000600008e-06),0) pd=max(2*((FE_W_POUT/ceil(FE_W_POUT/0.0001-1e-9)))+(1.2000000000600008e-06),0) m=FE_M_POUT*ceil(FE_W_POUT/0.0001-1e-9)
  M21 (X NG VDD VDD) pmos1 w=(FE_W_POUT/ceil(FE_W_POUT/0.0001-1e-9)) l=FE_L_POUT as=(5.999999999996845e-07*((FE_W_POUT/ceil(FE_W_POUT/0.0001-1e-9)))) ad=(5.999999999996845e-07*((FE_W_POUT/ceil(FE_W_POUT/0.0001-1e-9)))) ps=max(2*((FE_W_POUT/ceil(FE_W_POUT/0.0001-1e-9)))+(1.2000000000600008e-06),0) pd=max(2*((FE_W_POUT/ceil(FE_W_POUT/0.0001-1e-9)))+(1.2000000000600008e-06),0) m=FE_M_POUT*ceil(FE_W_POUT/0.0001-1e-9)
  M20 (NG PG VDD VDD) pmos1 w=(FE_W_PMIR/ceil(FE_W_PMIR/0.0001-1e-9)) l=FE_L_PMIR as=(6.000000000016381e-07*((FE_W_PMIR/ceil(FE_W_PMIR/0.0001-1e-9)))) ad=(6.000000000016381e-07*((FE_W_PMIR/ceil(FE_W_PMIR/0.0001-1e-9)))) ps=max(2*((FE_W_PMIR/ceil(FE_W_PMIR/0.0001-1e-9)))+(1.199999999980002e-06),0) pd=max(2*((FE_W_PMIR/ceil(FE_W_PMIR/0.0001-1e-9)))+(1.199999999980002e-06),0) m=FE_M_PMIR*ceil(FE_W_PMIR/0.0001-1e-9)
  M19 (PG PG VDD VDD) pmos1 w=(FE_W_PMIR/ceil(FE_W_PMIR/0.0001-1e-9)) l=FE_L_PMIR as=(6.000000000016381e-07*((FE_W_PMIR/ceil(FE_W_PMIR/0.0001-1e-9)))) ad=(6.000000000016381e-07*((FE_W_PMIR/ceil(FE_W_PMIR/0.0001-1e-9)))) ps=max(2*((FE_W_PMIR/ceil(FE_W_PMIR/0.0001-1e-9)))+(1.199999999980002e-06),0) pd=max(2*((FE_W_PMIR/ceil(FE_W_PMIR/0.0001-1e-9)))+(1.199999999980002e-06),0) m=FE_M_PMIR*ceil(FE_W_PMIR/0.0001-1e-9)
  M9 (PB NR VDD VDD) pmos1 w=(A1_W_PMIR/ceil(A1_W_PMIR/0.0001-1e-9)) l=A1_L_PMIR as=(6.000000000010123e-07*((A1_W_PMIR/ceil(A1_W_PMIR/0.0001-1e-9)))) ad=(6.000000000010123e-07*((A1_W_PMIR/ceil(A1_W_PMIR/0.0001-1e-9)))) ps=max(2*((A1_W_PMIR/ceil(A1_W_PMIR/0.0001-1e-9)))+(1.2000000000200005e-06),0) pd=max(2*((A1_W_PMIR/ceil(A1_W_PMIR/0.0001-1e-9)))+(1.2000000000200005e-06),0) m=A1_M_PMIR*ceil(A1_W_PMIR/0.0001-1e-9)
  M8 (OP2 NR VDD VDD) pmos1 w=(A1_W_PMIR/ceil(A1_W_PMIR/0.0001-1e-9)) l=A1_L_PMIR as=(6.000000000010123e-07*((A1_W_PMIR/ceil(A1_W_PMIR/0.0001-1e-9)))) ad=(6.000000000010123e-07*((A1_W_PMIR/ceil(A1_W_PMIR/0.0001-1e-9)))) ps=max(2*((A1_W_PMIR/ceil(A1_W_PMIR/0.0001-1e-9)))+(1.2000000000200005e-06),0) pd=max(2*((A1_W_PMIR/ceil(A1_W_PMIR/0.0001-1e-9)))+(1.2000000000200005e-06),0) m=A1_M_PMIR*ceil(A1_W_PMIR/0.0001-1e-9)
  M7 (OP NR VDD VDD) pmos1 w=(A1_W_PMIR/ceil(A1_W_PMIR/0.0001-1e-9)) l=A1_L_PMIR as=(6.000000000010123e-07*((A1_W_PMIR/ceil(A1_W_PMIR/0.0001-1e-9)))) ad=(6.000000000010123e-07*((A1_W_PMIR/ceil(A1_W_PMIR/0.0001-1e-9)))) ps=max(2*((A1_W_PMIR/ceil(A1_W_PMIR/0.0001-1e-9)))+(1.2000000000200005e-06),0) pd=max(2*((A1_W_PMIR/ceil(A1_W_PMIR/0.0001-1e-9)))+(1.2000000000200005e-06),0) m=A1_M_PMIR*ceil(A1_W_PMIR/0.0001-1e-9)
  M6 (NR NR VDD VDD) pmos1 w=(A1_W_PLD/ceil(A1_W_PLD/0.0001-1e-9)) l=A1_L_PLD as=(5.999999999993487e-07*((A1_W_PLD/ceil(A1_W_PLD/0.0001-1e-9)))) ad=(5.999999999993487e-07*((A1_W_PLD/ceil(A1_W_PLD/0.0001-1e-9)))) ps=max(2*((A1_W_PLD/ceil(A1_W_PLD/0.0001-1e-9)))+(1.2000000000999994e-06),0) pd=max(2*((A1_W_PLD/ceil(A1_W_PLD/0.0001-1e-9)))+(1.2000000000999994e-06),0) m=A1_M_PLD*ceil(A1_W_PLD/0.0001-1e-9)
  M5 (NL NL VDD VDD) pmos1 w=(A1_W_PLD/ceil(A1_W_PLD/0.0001-1e-9)) l=A1_L_PLD as=(5.999999999993487e-07*((A1_W_PLD/ceil(A1_W_PLD/0.0001-1e-9)))) ad=(5.999999999993487e-07*((A1_W_PLD/ceil(A1_W_PLD/0.0001-1e-9)))) ps=max(2*((A1_W_PLD/ceil(A1_W_PLD/0.0001-1e-9)))+(1.2000000000999994e-06),0) pd=max(2*((A1_W_PLD/ceil(A1_W_PLD/0.0001-1e-9)))+(1.2000000000999994e-06),0) m=A1_M_PLD*ceil(A1_W_PLD/0.0001-1e-9)
  M4 (NB NL VDD VDD) pmos1 w=(A1_W_PMIR/ceil(A1_W_PMIR/0.0001-1e-9)) l=A1_L_PMIR as=(6.000000000010123e-07*((A1_W_PMIR/ceil(A1_W_PMIR/0.0001-1e-9)))) ad=(6.000000000010123e-07*((A1_W_PMIR/ceil(A1_W_PMIR/0.0001-1e-9)))) ps=max(2*((A1_W_PMIR/ceil(A1_W_PMIR/0.0001-1e-9)))+(1.2000000000200005e-06),0) pd=max(2*((A1_W_PMIR/ceil(A1_W_PMIR/0.0001-1e-9)))+(1.2000000000200005e-06),0) m=A1_M_PMIR*ceil(A1_W_PMIR/0.0001-1e-9)
  M3 (OM NL VDD VDD) pmos1 w=(A1_W_PMIR/ceil(A1_W_PMIR/0.0001-1e-9)) l=A1_L_PMIR as=(6.000000000010123e-07*((A1_W_PMIR/ceil(A1_W_PMIR/0.0001-1e-9)))) ad=(6.000000000010123e-07*((A1_W_PMIR/ceil(A1_W_PMIR/0.0001-1e-9)))) ps=max(2*((A1_W_PMIR/ceil(A1_W_PMIR/0.0001-1e-9)))+(1.2000000000200005e-06),0) pd=max(2*((A1_W_PMIR/ceil(A1_W_PMIR/0.0001-1e-9)))+(1.2000000000200005e-06),0) m=A1_M_PMIR*ceil(A1_W_PMIR/0.0001-1e-9)
  IBIAS (T VSS) isource dc=A1_IBIAS type=dc
ends mdvccta_fig2_A1
subckt grounded_resistor_fig8a (GND P VC)
  parameters R1_L=1e-06 R1_M=1.0 R1_W=1e-06
  MR2 (P VC GND GND) nmos1 w=(R1_W/ceil(R1_W/0.0001-1e-9)) l=R1_L as=(5.999999999988889e-07*((R1_W/ceil(R1_W/0.0001-1e-9)))) ad=(5.999999999988889e-07*((R1_W/ceil(R1_W/0.0001-1e-9)))) ps=max(2*((R1_W/ceil(R1_W/0.0001-1e-9)))+(1.1999999999999987e-06),0) pd=max(2*((R1_W/ceil(R1_W/0.0001-1e-9)))+(1.1999999999999987e-06),0) m=R1_M*ceil(R1_W/0.0001-1e-9)
  MR1 (P P GND GND) nmos1 w=(R1_W/ceil(R1_W/0.0001-1e-9)) l=R1_L as=(5.999999999988889e-07*((R1_W/ceil(R1_W/0.0001-1e-9)))) ad=(5.999999999988889e-07*((R1_W/ceil(R1_W/0.0001-1e-9)))) ps=max(2*((R1_W/ceil(R1_W/0.0001-1e-9)))+(1.1999999999999987e-06),0) pd=max(2*((R1_W/ceil(R1_W/0.0001-1e-9)))+(1.1999999999999987e-06),0) m=R1_M*ceil(R1_W/0.0001-1e-9)
ends grounded_resistor_fig8a
subckt grounded_resistor_fig8a_R2 (GND P VC)
  parameters R2_L=1e-06 R2_M=1.0 R2_W=1e-06
  MR2 (P VC GND GND) nmos1 w=(R2_W/ceil(R2_W/0.0001-1e-9)) l=R2_L as=(5.999999999987657e-07*((R2_W/ceil(R2_W/0.0001-1e-9)))) ad=(5.999999999987657e-07*((R2_W/ceil(R2_W/0.0001-1e-9)))) ps=max(2*((R2_W/ceil(R2_W/0.0001-1e-9)))+(1.200000000000002e-06),0) pd=max(2*((R2_W/ceil(R2_W/0.0001-1e-9)))+(1.200000000000002e-06),0) m=R2_M*ceil(R2_W/0.0001-1e-9)
  MR1 (P P GND GND) nmos1 w=(R2_W/ceil(R2_W/0.0001-1e-9)) l=R2_L as=(5.999999999987657e-07*((R2_W/ceil(R2_W/0.0001-1e-9)))) ad=(5.999999999987657e-07*((R2_W/ceil(R2_W/0.0001-1e-9)))) ps=max(2*((R2_W/ceil(R2_W/0.0001-1e-9)))+(1.200000000000002e-06),0) pd=max(2*((R2_W/ceil(R2_W/0.0001-1e-9)))+(1.200000000000002e-06),0) m=R2_M*ceil(R2_W/0.0001-1e-9)
ends grounded_resistor_fig8a_R2
subckt miso_fig3 (GND I1 I2 I3 IOUT V1 V2 V3 VBIAS VCTRL VDD VOUT VSS)
parameters A2_W_IN=1e-06 A2_L_IN=1e-06 A2_M_IN=1.0 A2_W_PMIR=1e-06 A2_L_PMIR=1e-06 A2_M_PMIR=1.0 A2_W_PLD=1e-06 A2_L_PLD=1e-06 A2_W_NMIR=1e-06 A2_L_NMIR=1e-06 A2_W_NDIO=1e-06 A2_L_NDIO=1e-06 A2_IBIAS=1e-05 A1_W_IN=1e-06 A1_L_IN=1e-06 A1_M_IN=1.0 A1_W_PMIR=1e-06 A1_L_PMIR=1e-06 A1_M_PMIR=1.0 A1_W_PLD=1e-06 A1_L_PLD=1e-06 A1_W_NMIR=1e-06 A1_L_NMIR=1e-06 A1_W_NDIO=1e-06 A1_L_NDIO=1e-06 A1_IBIAS=1e-05 FE_W_IN=1e-06 FE_L_IN=1e-06 FE_W_PMIR=1e-06 FE_L_PMIR=1e-06 FE_W_POUT=1e-06 FE_L_POUT=1e-06 FE_W_NTAIL=1e-06 FE_L_NTAIL=1e-06 FE_W_NOUT=1e-06 FE_L_NOUT=1e-06 R1_W=1e-06 R1_L=1e-06 R2_W=1e-06 R2_L=1e-06 R3=10000.0 C1=1e-12 C2=1e-12 A2_M_PLD=1.0 A2_M_NMIR=1.0 A2_M_NDIO=1.0 A1_M_PLD=1.0 A1_M_NMIR=1.0 A1_M_NDIO=1.0 FE_M_IN=1.0 FE_M_PMIR=1.0 FE_M_POUT=1.0 FE_M_NTAIL=1.0 FE_M_NOUT=1.0 R1_M=1.0 R2_M=1.0
A2 (GND V1 I1 NOPB NOP2B VBIAS VDD VSS VOUT I1 GND IOUT NC2B I3) mdvccta_fig2 A2_IBIAS=A2_IBIAS A2_L_IN=A2_L_IN A2_L_NDIO=A2_L_NDIO A2_L_NMIR=A2_L_NMIR A2_L_PLD=A2_L_PLD A2_L_PMIR=A2_L_PMIR A2_M_IN=A2_M_IN A2_M_NDIO=A2_M_NDIO A2_M_NMIR=A2_M_NMIR A2_M_PLD=A2_M_PLD A2_M_PMIR=A2_M_PMIR A2_W_IN=A2_W_IN A2_W_NDIO=A2_W_NDIO A2_W_NMIR=A2_W_NMIR A2_W_PLD=A2_W_PLD A2_W_PMIR=A2_W_PMIR FE_L_IN=FE_L_IN FE_L_NOUT=FE_L_NOUT FE_L_NTAIL=FE_L_NTAIL FE_L_PMIR=FE_L_PMIR FE_L_POUT=FE_L_POUT FE_M_IN=FE_M_IN FE_M_NOUT=FE_M_NOUT FE_M_NTAIL=FE_M_NTAIL FE_M_PMIR=FE_M_PMIR FE_M_POUT=FE_M_POUT FE_W_IN=FE_W_IN FE_W_NOUT=FE_W_NOUT FE_W_NTAIL=FE_W_NTAIL FE_W_PMIR=FE_W_PMIR FE_W_POUT=FE_W_POUT
A1 (GND V3 I3 NOPA NOP2A VBIAS VDD VSS X1 V2 I1 NC1A NC2A I2) mdvccta_fig2_A1 A1_IBIAS=A1_IBIAS A1_L_IN=A1_L_IN A1_L_NDIO=A1_L_NDIO A1_L_NMIR=A1_L_NMIR A1_L_PLD=A1_L_PLD A1_L_PMIR=A1_L_PMIR A1_M_IN=A1_M_IN A1_M_NDIO=A1_M_NDIO A1_M_NMIR=A1_M_NMIR A1_M_PLD=A1_M_PLD A1_M_PMIR=A1_M_PMIR A1_W_IN=A1_W_IN A1_W_NDIO=A1_W_NDIO A1_W_NMIR=A1_W_NMIR A1_W_PLD=A1_W_PLD A1_W_PMIR=A1_W_PMIR FE_L_IN=FE_L_IN FE_L_NOUT=FE_L_NOUT FE_L_NTAIL=FE_L_NTAIL FE_L_PMIR=FE_L_PMIR FE_L_POUT=FE_L_POUT FE_M_IN=FE_M_IN FE_M_NOUT=FE_M_NOUT FE_M_NTAIL=FE_M_NTAIL FE_M_PMIR=FE_M_PMIR FE_M_POUT=FE_M_POUT FE_W_IN=FE_W_IN FE_W_NOUT=FE_W_NOUT FE_W_NTAIL=FE_W_NTAIL FE_W_PMIR=FE_W_PMIR FE_W_POUT=FE_W_POUT
R2 (GND VOUT VCTRL) grounded_resistor_fig8a_R2 R2_L=R2_L R2_M=R2_M R2_W=R2_W
R1 (GND X1 VCTRL) grounded_resistor_fig8a R1_L=R1_L R1_M=R1_M R1_W=R1_W
R3 (I1 GND) resistor r=R3
C2 (I3 GND) capacitor c=C2
C1 (I2 GND) capacitor c=C1
ends miso_fig3
