// Golden sizing netlist (curator 2026-10-28): the benchmark DUT subckt with its parameter defaults set to
// the golden design (golden_design.json), taken from the verified run's job NN_T60_S1p00/ldo_line_v1.
// The DUT subckt and its parameter values are the same in every job of that run (only the testbench changes).
// Instance line of that run: XDUT (vin b_VSS vref b_VBIAS b_ENABLE out) ldo24m_miller_dut C_EA=3.559701666949974e-13 C_F=1.2109464612028442e-11 L_CM=5.184219043653652e-07 L_EA2=1.99915252261674e-06 L_EAIN=2.24880190566467e-06 L_E...
// Testbench-level variables (bias sources, operating levels) are in golden_design.json and testbench decks.
// Generated by analogiq from final.scs (sha256 273b9afac138e670).
// Connectivity and device models are unchanged except for the listed transformations:
//   - M1: junction geometry ad/as/pd/ps rewritten in terms of the bound width (area = Lj*W, perimeter = 2*W + c; Lj and c from the netlist)
//   - M2: junction geometry ad/as/pd/ps rewritten in terms of the bound width (area = Lj*W, perimeter = 2*W + c; Lj and c from the netlist)
//   - M3: junction geometry ad/as/pd/ps rewritten in terms of the bound width (area = Lj*W, perimeter = 2*W + c; Lj and c from the netlist)
//   - M4: junction geometry ad/as/pd/ps rewritten in terms of the bound width (area = Lj*W, perimeter = 2*W + c; Lj and c from the netlist)
//   - loop-break iprobe IPRB_LOOP inserted between net VFB and terminal 1 of M4
//   - M5: junction geometry ad/as/pd/ps rewritten in terms of the bound width (area = Lj*W, perimeter = 2*W + c; Lj and c from the netlist)
//   - M7: junction geometry ad/as/pd/ps rewritten in terms of the bound width (area = Lj*W, perimeter = 2*W + c; Lj and c from the netlist)
//   - M6: junction geometry ad/as/pd/ps rewritten in terms of the bound width (area = Lj*W, perimeter = 2*W + c; Lj and c from the netlist)
//   - MC: junction geometry ad/as/pd/ps rewritten in terms of the bound width (area = Lj*W, perimeter = 2*W + c; Lj and c from the netlist)
//   - MP: junction geometry ad/as/pd/ps rewritten in terms of the bound width (area = Lj*W, perimeter = 2*W + c; Lj and c from the netlist)
//   - MRFB1: junction geometry ad/as/pd/ps rewritten in terms of the bound width (area = Lj*W, perimeter = 2*W + c; Lj and c from the netlist)
//   - MRFB2: junction geometry ad/as/pd/ps rewritten in terms of the bound width (area = Lj*W, perimeter = 2*W + c; Lj and c from the netlist)
//   - MRFB3: junction geometry ad/as/pd/ps rewritten in terms of the bound width (area = Lj*W, perimeter = 2*W + c; Lj and c from the netlist)
//   - MS: junction geometry ad/as/pd/ps rewritten in terms of the bound width (area = Lj*W, perimeter = 2*W + c; Lj and c from the netlist)
//   - MA1: junction geometry ad/as/pd/ps rewritten in terms of the bound width (area = Lj*W, perimeter = 2*W + c; Lj and c from the netlist)
//   - MA2: junction geometry ad/as/pd/ps rewritten in terms of the bound width (area = Lj*W, perimeter = 2*W + c; Lj and c from the netlist)
//   - MA3: junction geometry ad/as/pd/ps rewritten in terms of the bound width (area = Lj*W, perimeter = 2*W + c; Lj and c from the netlist)
//   - MA4: junction geometry ad/as/pd/ps rewritten in terms of the bound width (area = Lj*W, perimeter = 2*W + c; Lj and c from the netlist)
//   - MA5: junction geometry ad/as/pd/ps rewritten in terms of the bound width (area = Lj*W, perimeter = 2*W + c; Lj and c from the netlist)
//   - MA6: junction geometry ad/as/pd/ps rewritten in terms of the bound width (area = Lj*W, perimeter = 2*W + c; Lj and c from the netlist)
//   - MAB: junction geometry ad/as/pd/ps rewritten in terms of the bound width (area = Lj*W, perimeter = 2*W + c; Lj and c from the netlist)
subckt ldo24m_miller_dut (VIN VSS VREF VBIAS ENABLE VOUT)
parameters W_EAL=1.239447261577426e-06 L_EAL=1.2333384268444895e-06 W_EAIN=1.417535532684865e-05 L_EAIN=2.24880190566467e-06 W_EAT=1.379967110649612e-05 L_EAT=2.9970193646535408e-06 W_EAS=2.241586840284553e-06 L_EAS=1.616078556483745e-06 W_EA2=4.8813348474016104e-05 L_EA2=1.99915252261674e-06 W_MCR=1.4050021313860443e-06 L_MCR=7.603922072908872e-06 C_EA=3.559701666949974e-13 W_PASS=1.6922855977643836e-05 N_PASS=243.0 L_PASS=3.0031879113208985e-07 W_RFB=1.3620807697516766e-05 L_RFB=7.371708438376383e-07 W_MSW=5.010609552037965e-05 L_MSW=4.186824600793429e-07 W_CM=3.3838201067244906e-06 L_CM=5.184219043653652e-07 W_WLS=6.4959250892237435e-06 L_WLS=1.3360342093575552e-06 W_WLB=1.5486743372861277e-05 L_WLB=9.458726116173424e-07 W_MAB=5.869974442355513e-06 L_MAB=6.798880437184044e-07 C_F=1.2109464612028442e-11
M1 (N1 N1 VIN VIN) pmos25 w=W_EAL l=L_EAL m=1 ad=(6e-07*(W_EAL)) as=(6e-07*(W_EAL)) pd=max(2*(W_EAL)+(1.200000000000002e-06),0) ps=max(2*(W_EAL)+(1.200000000000002e-06),0)
M2 (N2 N1 VIN VIN) pmos25 w=W_EAL l=L_EAL m=1 ad=(6e-07*(W_EAL)) as=(6e-07*(W_EAL)) pd=max(2*(W_EAL)+(1.200000000000002e-06),0) ps=max(2*(W_EAL)+(1.200000000000002e-06),0)
M3 (N1 VREF TAIL VSS) nmos25 w=W_EAIN l=L_EAIN m=1 ad=(6e-07*(W_EAIN)) as=(6e-07*(W_EAIN)) pd=max(2*(W_EAIN)+(1.1999999999999987e-06),0) ps=max(2*(W_EAIN)+(1.1999999999999987e-06),0)
IPRB_LOOP (VFB VFB__lp) iprobe
M4 (N2 VFB__lp TAIL VSS) nmos25 w=W_EAIN l=L_EAIN m=1 ad=(6e-07*(W_EAIN)) as=(6e-07*(W_EAIN)) pd=max(2*(W_EAIN)+(1.1999999999999987e-06),0) ps=max(2*(W_EAIN)+(1.1999999999999987e-06),0)
M5 (TAIL VBIAS VSS VSS) nmos25 w=W_EAT l=L_EAT m=1 ad=(6.000000000000001e-07*(W_EAT)) as=(6.000000000000001e-07*(W_EAT)) pd=max(2*(W_EAT)+(1.2000000000000004e-06),0) ps=max(2*(W_EAT)+(1.2000000000000004e-06),0)
M7 (VG N2 VIN VIN) pmos25 w=W_EA2 l=L_EA2 m=1 ad=(6e-07*(W_EA2)) as=(6e-07*(W_EA2)) pd=max(2*(W_EA2)+(1.200000000000002e-06),0) ps=max(2*(W_EA2)+(1.200000000000002e-06),0)
M6 (VG VBIAS VSS VSS) nmos25 w=W_EAS l=L_EAS m=1 ad=(6e-07*(W_EAS)) as=(6e-07*(W_EAS)) pd=max(2*(W_EAS)+(1.200000000000002e-06),0) ps=max(2*(W_EAS)+(1.200000000000002e-06),0)
MC (NCC VSS N2 VIN) pmos25 w=W_MCR l=L_MCR m=1 ad=(6e-07*(W_MCR)) as=(6e-07*(W_MCR)) pd=max(2*(W_MCR)+(1.2000000000000004e-06),0) ps=max(2*(W_MCR)+(1.2000000000000004e-06),0)
CC (NCC VG) capacitor c=C_EA
MP (VOUT VG VIN VIN) pmos25 w=W_PASS l=L_PASS m=N_PASS ad=(6.000000000000001e-07*(W_PASS)) as=(6.000000000000001e-07*(W_PASS)) pd=max(2*(W_PASS)+(1.200000000000002e-06),0) ps=max(2*(W_PASS)+(1.200000000000002e-06),0)
MRFB1 (VFB VFB VOUT VOUT) pmos25 w=W_RFB l=L_RFB m=1 ad=(6.000000000000001e-07*(W_RFB)) as=(6.000000000000001e-07*(W_RFB)) pd=max(2*(W_RFB)+(1.1999999999999987e-06),0) ps=max(2*(W_RFB)+(1.1999999999999987e-06),0)
MRFB2 (FBMID FBMID VFB VFB) pmos25 w=W_RFB l=L_RFB m=1 ad=(6.000000000000001e-07*(W_RFB)) as=(6.000000000000001e-07*(W_RFB)) pd=max(2*(W_RFB)+(1.1999999999999987e-06),0) ps=max(2*(W_RFB)+(1.1999999999999987e-06),0)
MRFB3 (VSS VSS FBMID FBMID) pmos25 w=W_RFB l=L_RFB m=1 ad=(6.000000000000001e-07*(W_RFB)) as=(6.000000000000001e-07*(W_RFB)) pd=max(2*(W_RFB)+(1.1999999999999987e-06),0) ps=max(2*(W_RFB)+(1.1999999999999987e-06),0)
MS (VOUT ENABLE VFB VSS) nmos25 w=W_MSW l=L_MSW m=1 ad=(6.000000000000001e-07*(W_MSW)) as=(6.000000000000001e-07*(W_MSW)) pd=max(2*(W_MSW)+(1.2e-06),0) ps=max(2*(W_MSW)+(1.2e-06),0)
MA1 (NCF NCF VIN VIN) pmos25 w=W_CM l=L_CM m=1 ad=(6e-07*(W_CM)) as=(6e-07*(W_CM)) pd=max(2*(W_CM)+(1.2000000000000004e-06),0) ps=max(2*(W_CM)+(1.2000000000000004e-06),0)
MA2 (NA3 NCF VIN VIN) pmos25 w=W_CM l=L_CM m=1 ad=(6e-07*(W_CM)) as=(6e-07*(W_CM)) pd=max(2*(W_CM)+(1.2000000000000004e-06),0) ps=max(2*(W_CM)+(1.2000000000000004e-06),0)
MA3 (NA3 NA3 NA6 VSS) nmos25 w=W_WLS l=L_WLS m=1 ad=(6.000000000000001e-07*(W_WLS)) as=(6.000000000000001e-07*(W_WLS)) pd=max(2*(W_WLS)+(1.2e-06),0) ps=max(2*(W_WLS)+(1.2e-06),0)
MA4 (VG NA3 NA5 VSS) nmos25 w=W_WLB l=L_WLB m=1 ad=(6e-07*(W_WLB)) as=(6e-07*(W_WLB)) pd=max(2*(W_WLB)+(1.200000000000002e-06),0) ps=max(2*(W_WLB)+(1.200000000000002e-06),0)
MA5 (NA5 NA5 VSS VSS) nmos25 w=W_WLB l=L_WLB m=1 ad=(6e-07*(W_WLB)) as=(6e-07*(W_WLB)) pd=max(2*(W_WLB)+(1.200000000000002e-06),0) ps=max(2*(W_WLB)+(1.200000000000002e-06),0)
MA6 (NA6 NA5 VSS VSS) nmos25 w=W_WLS l=L_WLS m=1 ad=(6.000000000000001e-07*(W_WLS)) as=(6.000000000000001e-07*(W_WLS)) pd=max(2*(W_WLS)+(1.2e-06),0) ps=max(2*(W_WLS)+(1.2e-06),0)
MAB (NCF VBIAS VSS VSS) nmos25 w=W_MAB l=L_MAB m=1 ad=(6.000000000000001e-07*(W_MAB)) as=(6.000000000000001e-07*(W_MAB)) pd=max(2*(W_MAB)+(1.2e-06),0) ps=max(2*(W_MAB)+(1.2e-06),0)
CF (NCF VOUT) capacitor c=C_F
ends ldo24m_miller_dut
