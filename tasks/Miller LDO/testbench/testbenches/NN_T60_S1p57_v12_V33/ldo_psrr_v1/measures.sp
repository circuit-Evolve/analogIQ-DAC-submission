* analogiq 0.1.0 testbench - generated, do not edit
* task ldo24m_miller_task_001  topology ldo24m_miller
* recipe ldo_psrr_v1 v2  condition NN_T60_S1p57_v12_V33 (models NN, 60 C, supply 3.3 V)
* request ldo24m_miller_task_001__plan  candidate ac77f2a3c8da6cc8
* execution profile search_full
* .measure statements (SPICE syntax), included by input.scs. Results: input.measure.
.option measdgt=10
.measure ac g00 find vdb(out) at=1000.0
