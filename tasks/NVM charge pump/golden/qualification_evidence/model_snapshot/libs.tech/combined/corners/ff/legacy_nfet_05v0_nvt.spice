* sky130_fd_pr__nfet_05v0_nvt legacy parameters (ff) for cap_vpp_11p3x11p8_..._nhv
* added by convert_spectre.py: missing from upstream libs.tech/combined
.param
+ sky130_fd_pr__nfet_05v0_nvt__wlod_diff = 0.0
+ sky130_fd_pr__nfet_05v0_nvt__wkvth0_diff = .8e-6
+ sky130_fd_pr__nfet_05v0_nvt__wku0_diff = .2e-6
+ sky130_fd_pr__nfet_05v0_nvt__wint_diff = -2.252e-8
+ sky130_fd_pr__nfet_05v0_nvt__vth0_slope_spectre = 0.0
+ sky130_fd_pr__nfet_05v0_nvt__vth0_slope = 0.0012
+ sky130_fd_pr__nfet_05v0_nvt__vth0_diff_1 = -0.018137
+ sky130_fd_pr__nfet_05v0_nvt__vsat_diff_1 = 0.0
+ sky130_fd_pr__nfet_05v0_nvt__voff_slope_spectre = 0.0
+ sky130_fd_pr__nfet_05v0_nvt__voff_slope = 0.0035
+ sky130_fd_pr__nfet_05v0_nvt__voff_diff_1 = 0.0
+ sky130_fd_pr__nfet_05v0_nvt__ub_diff_1 = -1.357e-18
+ sky130_fd_pr__nfet_05v0_nvt__ua_diff_1 = -2.636e-11
+ sky130_fd_pr__nfet_05v0_nvt__u0_diff_1 = -0.0077525
+ sky130_fd_pr__nfet_05v0_nvt__tvoff_diff_1 = 0.0
+ sky130_fd_pr__nfet_05v0_nvt__toxe_slope_spectre = 0.0
+ sky130_fd_pr__nfet_05v0_nvt__toxe_slope = 0.105e-2
+ sky130_fd_pr__nfet_05v0_nvt__toxe_mult = 0.9635
+ sky130_fd_pr__nfet_05v0_nvt__rshn_mult = 1.0
+ sky130_fd_pr__nfet_05v0_nvt__rdsw_diff_1 = 0.0
+ sky130_fd_pr__nfet_05v0_nvt__pjunction_mult = 9.0190e-1
+ sky130_fd_pr__nfet_05v0_nvt__pditsd_diff_1 = 0.0
+ sky130_fd_pr__nfet_05v0_nvt__pdits_diff_1 = 0.0
+ sky130_fd_pr__nfet_05v0_nvt__pclm_diff_1 = 0.0
+ sky130_fd_pr__nfet_05v0_nvt__overlap_mult = 5.1025e-1
+ sky130_fd_pr__nfet_05v0_nvt__nfactor_slope_spectre = 0.0
+ sky130_fd_pr__nfet_05v0_nvt__nfactor_slope = 0.02
+ sky130_fd_pr__nfet_05v0_nvt__nfactor_diff_1 = -0.019967
+ sky130_fd_pr__nfet_05v0_nvt__lkvth0_diff = 0.0
+ sky130_fd_pr__nfet_05v0_nvt__lku0_diff = 0.0
+ sky130_fd_pr__nfet_05v0_nvt__lint_diff = 1.21275e-8
+ sky130_fd_pr__nfet_05v0_nvt__kvth0_diff = -7.0e-9
+ sky130_fd_pr__nfet_05v0_nvt__kvsat_diff = 0.4
+ sky130_fd_pr__nfet_05v0_nvt__ku0_diff = -3.0e-8
+ sky130_fd_pr__nfet_05v0_nvt__kt1_diff_1 = 0.0
+ sky130_fd_pr__nfet_05v0_nvt__keta_diff_1 = 0.0
+ sky130_fd_pr__nfet_05v0_nvt__k2_diff_1 = -0.0051327
+ sky130_fd_pr__nfet_05v0_nvt__eta0_diff_1 = 0.0
+ sky130_fd_pr__nfet_05v0_nvt__dwc_diff = -2.252e-8
+ sky130_fd_pr__nfet_05v0_nvt__dlc_rotweak = hv_dlc_rotweak
+ sky130_fd_pr__nfet_05v0_nvt__dlc_diff = 1.6112e-8
+ sky130_fd_pr__nfet_05v0_nvt__b1_diff_1 = 0.0
+ sky130_fd_pr__nfet_05v0_nvt__b0_diff_1 = 0.0
+ sky130_fd_pr__nfet_05v0_nvt__ajunction_mult = 6.8772e-1
+ sky130_fd_pr__nfet_05v0_nvt__ags_diff_1 = -0.0051202
+ sky130_fd_pr__nfet_05v0_nvt__a0_diff_1 = -0.032965
