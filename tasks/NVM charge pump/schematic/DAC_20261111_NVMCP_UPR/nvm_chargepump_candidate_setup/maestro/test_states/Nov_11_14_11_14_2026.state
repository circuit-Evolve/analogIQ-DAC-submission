ADE simulation setup
Test Pump_startup_and_steady_state: DAC_20261111_NVMCP_UPR/nvm_chargepump_candidate_tb/schematic, simulator spectre
  Output output_voltage_V = if((abs((average(clip(getData("OUT" ?result "tran") 0.000295 0.0003)) - average(clip(getData("OUT" ?result "tran") 0.00029 0.000295)))) < 0.00020345) then average(clip(getData("OUT" ?result "tran") 0.000295 0.0003)) else nil)
  Output ripple_mV = if((abs((average(clip(getData("OUT" ?result "tran") 0.000295 0.0003)) - average(clip(getData("OUT" ?result "tran") 0.00029 0.000295)))) < 0.00020345) then (1000 * (ymax(clip(getData("OUT" ?result "tran") 0.000295 0.0003)) - ymin(clip(getData("OUT" ?result "tran") 0.000295 0.0003)))) else nil)
  Output input_power_mW = if((abs((average(clip(getData("OUT" ?result "tran") 0.000295 0.0003)) - average(clip(getData("OUT" ?result "tran") 0.00029 0.000295)))) < 0.00020345) then (1000 * average(clip((((- getData("VDD" ?result "tran")) * getData("VDD_SRC:p" ?result "tran")) - (getData("CLKA" ?result "tran") * getData("CLK_A:p" ?result "tran")) - (getData("CLKB" ?result "tran") * getData("CLK_B:p" ?result "tran"))) 0.000295 0.0003))) else nil)
  Output output_power_uW = if((abs((average(clip(getData("OUT" ?result "tran") 0.000295 0.0003)) - average(clip(getData("OUT" ?result "tran") 0.00029 0.000295)))) < 0.00020345) then (1000000.0 * average(clip(((getData("OUT" ?result "tran") * getData("OUT" ?result "tran")) / 1000000.0) 0.000295 0.0003))) else nil)
  Output efficiency_percent = if((abs((average(clip(getData("OUT" ?result "tran") 0.000295 0.0003)) - average(clip(getData("OUT" ?result "tran") 0.00029 0.000295)))) < 0.00020345) then ((100 * average(clip(((getData("OUT" ?result "tran") * getData("OUT" ?result "tran")) / 1000000.0) 0.000295 0.0003))) / average(clip((((- getData("VDD" ?result "tran")) * getData("VDD_SRC:p" ?result "tran")) - (getData("CLKA" ?result "tran") * getData("CLK_A:p" ?result "tran")) - (getData("CLKB" ?result "tran") * getData("CLK_B:p" ?result "tran"))) 0.000295 0.0003))) else nil)
  Output rise_time_us = if((abs((average(clip(getData("OUT" ?result "tran") 0.000295 0.0003)) - average(clip(getData("OUT" ?result "tran") 0.00029 0.000295)))) < 0.00020345) then (1000000.0 * (cross(getData("OUT" ?result "tran") (0.9 * average(clip(getData("OUT" ?result "tran") 0.000295 0.0003))) 1 "rising" nil nil) - cross(getData("OUT" ?result "tran") (0.1 * average(clip(getData("OUT" ?result "tran") 0.000295 0.0003))) 1 "rising" nil nil))) else nil)
