// Generated by analogiq from dut_benchmark.scs (sha256 70f0a368bacc9350).
// Connectivity and device models are unchanged except for the listed transformations:
//   - M1NA: junction geometry ad/as/pd/ps rewritten in terms of the bound width (area = Lj*W, perimeter = 2*W + c; Lj and c from the netlist)
//   - M1NB: junction geometry ad/as/pd/ps rewritten in terms of the bound width (area = Lj*W, perimeter = 2*W + c; Lj and c from the netlist)
//   - M1PA: junction geometry ad/as/pd/ps rewritten in terms of the bound width (area = Lj*W, perimeter = 2*W + c; Lj and c from the netlist)
//   - M1PB: junction geometry ad/as/pd/ps rewritten in terms of the bound width (area = Lj*W, perimeter = 2*W + c; Lj and c from the netlist)
//   - M2NA: junction geometry ad/as/pd/ps rewritten in terms of the bound width (area = Lj*W, perimeter = 2*W + c; Lj and c from the netlist)
//   - M2NB: junction geometry ad/as/pd/ps rewritten in terms of the bound width (area = Lj*W, perimeter = 2*W + c; Lj and c from the netlist)
//   - M2PA: junction geometry ad/as/pd/ps rewritten in terms of the bound width (area = Lj*W, perimeter = 2*W + c; Lj and c from the netlist)
//   - M2PB: junction geometry ad/as/pd/ps rewritten in terms of the bound width (area = Lj*W, perimeter = 2*W + c; Lj and c from the netlist)
//   - M3NA: junction geometry ad/as/pd/ps rewritten in terms of the bound width (area = Lj*W, perimeter = 2*W + c; Lj and c from the netlist)
//   - M3NB: junction geometry ad/as/pd/ps rewritten in terms of the bound width (area = Lj*W, perimeter = 2*W + c; Lj and c from the netlist)
//   - M3PA: junction geometry ad/as/pd/ps rewritten in terms of the bound width (area = Lj*W, perimeter = 2*W + c; Lj and c from the netlist)
//   - M3PB: junction geometry ad/as/pd/ps rewritten in terms of the bound width (area = Lj*W, perimeter = 2*W + c; Lj and c from the netlist)
//   - M4NA: junction geometry ad/as/pd/ps rewritten in terms of the bound width (area = Lj*W, perimeter = 2*W + c; Lj and c from the netlist)
//   - M4NB: junction geometry ad/as/pd/ps rewritten in terms of the bound width (area = Lj*W, perimeter = 2*W + c; Lj and c from the netlist)
//   - M4PA: junction geometry ad/as/pd/ps rewritten in terms of the bound width (area = Lj*W, perimeter = 2*W + c; Lj and c from the netlist)
//   - M4PB: junction geometry ad/as/pd/ps rewritten in terms of the bound width (area = Lj*W, perimeter = 2*W + c; Lj and c from the netlist)
//   - M5NA: junction geometry ad/as/pd/ps rewritten in terms of the bound width (area = Lj*W, perimeter = 2*W + c; Lj and c from the netlist)
//   - M5NB: junction geometry ad/as/pd/ps rewritten in terms of the bound width (area = Lj*W, perimeter = 2*W + c; Lj and c from the netlist)
//   - M5PA: junction geometry ad/as/pd/ps rewritten in terms of the bound width (area = Lj*W, perimeter = 2*W + c; Lj and c from the netlist)
//   - M5PB: junction geometry ad/as/pd/ps rewritten in terms of the bound width (area = Lj*W, perimeter = 2*W + c; Lj and c from the netlist)
//   - M6NA: junction geometry ad/as/pd/ps rewritten in terms of the bound width (area = Lj*W, perimeter = 2*W + c; Lj and c from the netlist)
//   - M6NB: junction geometry ad/as/pd/ps rewritten in terms of the bound width (area = Lj*W, perimeter = 2*W + c; Lj and c from the netlist)
//   - M6PA: junction geometry ad/as/pd/ps rewritten in terms of the bound width (area = Lj*W, perimeter = 2*W + c; Lj and c from the netlist)
//   - M6PB: junction geometry ad/as/pd/ps rewritten in terms of the bound width (area = Lj*W, perimeter = 2*W + c; Lj and c from the netlist)
//   - netlist parameters bound to sizing variables: S1_WN <- S1_WN, S1_WP <- S1_WP, S2_WN <- S2_WN, S2_WP <- S2_WP, S3_WN <- S3_WN, S3_WP <- S3_WP, S4_WN <- S4_WN, S4_WP <- S4_WP, S5_WN <- S5_WN, S5_WP <- S5_WP, S6_WN <- S6_WN, S6_WP <- S6_WP
subckt NVM_CP (VDD CLKA CLKB OUT GND)
parameters S1_WN=1e-06 S1_WP=1e-06 S1_LN=9.079999999999999e-07 S1_LP=1e-06 S1_CF=1e-12 S1_CS=1e-12 S2_WN=1e-06 S2_WP=1e-06 S2_LN=9.079999999999999e-07 S2_LP=1e-06 S2_CF=1e-12 S2_CS=1e-12 S3_WN=1e-06 S3_WP=1e-06 S3_LN=9.079999999999999e-07 S3_LP=1e-06 S3_CF=1e-12 S3_CS=1e-12 S4_WN=1e-06 S4_WP=1e-06 S4_LN=9.079999999999999e-07 S4_LP=1e-06 S4_CF=1e-12 S4_CS=1e-12 S5_WN=1e-06 S5_WP=1e-06 S5_LN=9.079999999999999e-07 S5_LP=1e-06 S5_CF=1e-12 S5_CS=1e-12 S6_WN=1e-06 S6_WP=1e-06 S6_LN=9.079999999999999e-07 S6_LP=1e-06 S6_CF=1e-12 S6_CS=1e-12 S1_N_NF=1.0 S1_N_M=1.0 S1_P_NF=1.0 S1_P_M=1.0 S2_N_NF=1.0 S2_N_M=1.0 S2_P_NF=1.0 S2_P_M=1.0 S3_N_NF=1.0 S3_N_M=1.0 S3_P_NF=1.0 S3_P_M=1.0 S4_N_NF=1.0 S4_N_M=1.0 S4_P_NF=1.0 S4_P_M=1.0 S5_N_NF=1.0 S5_N_M=1.0 S5_P_NF=1.0 S5_P_M=1.0 S6_N_NF=1.0 S6_N_M=1.0 S6_P_NF=1.0 S6_P_M=1.0
M1NA (A1 B1 VDD VDD) sky130_fd_pr__nfet_03v3_nvt w=((S1_WN * S1_N_NF)/1e-06) l=(S1_LN/1e-06) nf=S1_N_NF m=S1_N_M ad=(0.29*(((S1_WN * S1_N_NF)/1e-06))) as=(0.29*(((S1_WN * S1_N_NF)/1e-06))) pd=max(2*(((S1_WN * S1_N_NF)/1e-06))+(0.5800000000000001),0) ps=max(2*(((S1_WN * S1_N_NF)/1e-06))+(0.5800000000000001),0)
M1NB (B1 A1 VDD VDD) sky130_fd_pr__nfet_03v3_nvt w=((S1_WN * S1_N_NF)/1e-06) l=(S1_LN/1e-06) nf=S1_N_NF m=S1_N_M ad=(0.29*(((S1_WN * S1_N_NF)/1e-06))) as=(0.29*(((S1_WN * S1_N_NF)/1e-06))) pd=max(2*(((S1_WN * S1_N_NF)/1e-06))+(0.5800000000000001),0) ps=max(2*(((S1_WN * S1_N_NF)/1e-06))+(0.5800000000000001),0)
M1PA (A1 B1 S1 S1) sky130_fd_pr__pfet_g5v0d10v5 w=((S1_WP * S1_P_NF)/1e-06) l=(S1_LP/1e-06) nf=S1_P_NF m=S1_P_M ad=(0.29000000000000004*(((S1_WP * S1_P_NF)/1e-06))) as=(0.29000000000000004*(((S1_WP * S1_P_NF)/1e-06))) pd=max(2*(((S1_WP * S1_P_NF)/1e-06))+(0.5800000000000005),0) ps=max(2*(((S1_WP * S1_P_NF)/1e-06))+(0.5800000000000005),0)
M1PB (B1 A1 S1 S1) sky130_fd_pr__pfet_g5v0d10v5 w=((S1_WP * S1_P_NF)/1e-06) l=(S1_LP/1e-06) nf=S1_P_NF m=S1_P_M ad=(0.29000000000000004*(((S1_WP * S1_P_NF)/1e-06))) as=(0.29000000000000004*(((S1_WP * S1_P_NF)/1e-06))) pd=max(2*(((S1_WP * S1_P_NF)/1e-06))+(0.5800000000000005),0) ps=max(2*(((S1_WP * S1_P_NF)/1e-06))+(0.5800000000000005),0)
C1A (A1 CLKA) capacitor c=S1_CF
C1B (B1 CLKB) capacitor c=S1_CF
C1S (S1 GND) capacitor c=S1_CS
M2NA (A2 B2 S1 S1) sky130_fd_pr__nfet_03v3_nvt w=((S2_WN * S2_N_NF)/1e-06) l=(S2_LN/1e-06) nf=S2_N_NF m=S2_N_M ad=(0.29*(((S2_WN * S2_N_NF)/1e-06))) as=(0.29*(((S2_WN * S2_N_NF)/1e-06))) pd=max(2*(((S2_WN * S2_N_NF)/1e-06))+(0.5800000000000001),0) ps=max(2*(((S2_WN * S2_N_NF)/1e-06))+(0.5800000000000001),0)
M2NB (B2 A2 S1 S1) sky130_fd_pr__nfet_03v3_nvt w=((S2_WN * S2_N_NF)/1e-06) l=(S2_LN/1e-06) nf=S2_N_NF m=S2_N_M ad=(0.29*(((S2_WN * S2_N_NF)/1e-06))) as=(0.29*(((S2_WN * S2_N_NF)/1e-06))) pd=max(2*(((S2_WN * S2_N_NF)/1e-06))+(0.5800000000000001),0) ps=max(2*(((S2_WN * S2_N_NF)/1e-06))+(0.5800000000000001),0)
M2PA (A2 B2 S2 S2) sky130_fd_pr__pfet_g5v0d10v5 w=((S2_WP * S2_P_NF)/1e-06) l=(S2_LP/1e-06) nf=S2_P_NF m=S2_P_M ad=(0.29000000000000004*(((S2_WP * S2_P_NF)/1e-06))) as=(0.29000000000000004*(((S2_WP * S2_P_NF)/1e-06))) pd=max(2*(((S2_WP * S2_P_NF)/1e-06))+(0.5800000000000005),0) ps=max(2*(((S2_WP * S2_P_NF)/1e-06))+(0.5800000000000005),0)
M2PB (B2 A2 S2 S2) sky130_fd_pr__pfet_g5v0d10v5 w=((S2_WP * S2_P_NF)/1e-06) l=(S2_LP/1e-06) nf=S2_P_NF m=S2_P_M ad=(0.29000000000000004*(((S2_WP * S2_P_NF)/1e-06))) as=(0.29000000000000004*(((S2_WP * S2_P_NF)/1e-06))) pd=max(2*(((S2_WP * S2_P_NF)/1e-06))+(0.5800000000000005),0) ps=max(2*(((S2_WP * S2_P_NF)/1e-06))+(0.5800000000000005),0)
C2A (A2 CLKA) capacitor c=S2_CF
C2B (B2 CLKB) capacitor c=S2_CF
C2S (S2 GND) capacitor c=S2_CS
M3NA (A3 B3 S2 S2) sky130_fd_pr__nfet_03v3_nvt w=((S3_WN * S3_N_NF)/1e-06) l=(S3_LN/1e-06) nf=S3_N_NF m=S3_N_M ad=(0.29*(((S3_WN * S3_N_NF)/1e-06))) as=(0.29*(((S3_WN * S3_N_NF)/1e-06))) pd=max(2*(((S3_WN * S3_N_NF)/1e-06))+(0.5800000000000001),0) ps=max(2*(((S3_WN * S3_N_NF)/1e-06))+(0.5800000000000001),0)
M3NB (B3 A3 S2 S2) sky130_fd_pr__nfet_03v3_nvt w=((S3_WN * S3_N_NF)/1e-06) l=(S3_LN/1e-06) nf=S3_N_NF m=S3_N_M ad=(0.29*(((S3_WN * S3_N_NF)/1e-06))) as=(0.29*(((S3_WN * S3_N_NF)/1e-06))) pd=max(2*(((S3_WN * S3_N_NF)/1e-06))+(0.5800000000000001),0) ps=max(2*(((S3_WN * S3_N_NF)/1e-06))+(0.5800000000000001),0)
M3PA (A3 B3 S3 S3) sky130_fd_pr__pfet_g5v0d10v5 w=((S3_WP * S3_P_NF)/1e-06) l=(S3_LP/1e-06) nf=S3_P_NF m=S3_P_M ad=(0.29000000000000004*(((S3_WP * S3_P_NF)/1e-06))) as=(0.29000000000000004*(((S3_WP * S3_P_NF)/1e-06))) pd=max(2*(((S3_WP * S3_P_NF)/1e-06))+(0.5800000000000005),0) ps=max(2*(((S3_WP * S3_P_NF)/1e-06))+(0.5800000000000005),0)
M3PB (B3 A3 S3 S3) sky130_fd_pr__pfet_g5v0d10v5 w=((S3_WP * S3_P_NF)/1e-06) l=(S3_LP/1e-06) nf=S3_P_NF m=S3_P_M ad=(0.29000000000000004*(((S3_WP * S3_P_NF)/1e-06))) as=(0.29000000000000004*(((S3_WP * S3_P_NF)/1e-06))) pd=max(2*(((S3_WP * S3_P_NF)/1e-06))+(0.5800000000000005),0) ps=max(2*(((S3_WP * S3_P_NF)/1e-06))+(0.5800000000000005),0)
C3A (A3 CLKA) capacitor c=S3_CF
C3B (B3 CLKB) capacitor c=S3_CF
C3S (S3 GND) capacitor c=S3_CS
M4NA (A4 B4 S3 S3) sky130_fd_pr__nfet_03v3_nvt w=((S4_WN * S4_N_NF)/1e-06) l=(S4_LN/1e-06) nf=S4_N_NF m=S4_N_M ad=(0.29*(((S4_WN * S4_N_NF)/1e-06))) as=(0.29*(((S4_WN * S4_N_NF)/1e-06))) pd=max(2*(((S4_WN * S4_N_NF)/1e-06))+(0.5800000000000001),0) ps=max(2*(((S4_WN * S4_N_NF)/1e-06))+(0.5800000000000001),0)
M4NB (B4 A4 S3 S3) sky130_fd_pr__nfet_03v3_nvt w=((S4_WN * S4_N_NF)/1e-06) l=(S4_LN/1e-06) nf=S4_N_NF m=S4_N_M ad=(0.29*(((S4_WN * S4_N_NF)/1e-06))) as=(0.29*(((S4_WN * S4_N_NF)/1e-06))) pd=max(2*(((S4_WN * S4_N_NF)/1e-06))+(0.5800000000000001),0) ps=max(2*(((S4_WN * S4_N_NF)/1e-06))+(0.5800000000000001),0)
M4PA (A4 B4 S4 S4) sky130_fd_pr__pfet_g5v0d10v5 w=((S4_WP * S4_P_NF)/1e-06) l=(S4_LP/1e-06) nf=S4_P_NF m=S4_P_M ad=(0.29000000000000004*(((S4_WP * S4_P_NF)/1e-06))) as=(0.29000000000000004*(((S4_WP * S4_P_NF)/1e-06))) pd=max(2*(((S4_WP * S4_P_NF)/1e-06))+(0.5800000000000005),0) ps=max(2*(((S4_WP * S4_P_NF)/1e-06))+(0.5800000000000005),0)
M4PB (B4 A4 S4 S4) sky130_fd_pr__pfet_g5v0d10v5 w=((S4_WP * S4_P_NF)/1e-06) l=(S4_LP/1e-06) nf=S4_P_NF m=S4_P_M ad=(0.29000000000000004*(((S4_WP * S4_P_NF)/1e-06))) as=(0.29000000000000004*(((S4_WP * S4_P_NF)/1e-06))) pd=max(2*(((S4_WP * S4_P_NF)/1e-06))+(0.5800000000000005),0) ps=max(2*(((S4_WP * S4_P_NF)/1e-06))+(0.5800000000000005),0)
C4A (A4 CLKA) capacitor c=S4_CF
C4B (B4 CLKB) capacitor c=S4_CF
C4S (S4 GND) capacitor c=S4_CS
M5NA (A5 B5 S4 S4) sky130_fd_pr__nfet_03v3_nvt w=((S5_WN * S5_N_NF)/1e-06) l=(S5_LN/1e-06) nf=S5_N_NF m=S5_N_M ad=(0.29*(((S5_WN * S5_N_NF)/1e-06))) as=(0.29*(((S5_WN * S5_N_NF)/1e-06))) pd=max(2*(((S5_WN * S5_N_NF)/1e-06))+(0.5800000000000001),0) ps=max(2*(((S5_WN * S5_N_NF)/1e-06))+(0.5800000000000001),0)
M5NB (B5 A5 S4 S4) sky130_fd_pr__nfet_03v3_nvt w=((S5_WN * S5_N_NF)/1e-06) l=(S5_LN/1e-06) nf=S5_N_NF m=S5_N_M ad=(0.29*(((S5_WN * S5_N_NF)/1e-06))) as=(0.29*(((S5_WN * S5_N_NF)/1e-06))) pd=max(2*(((S5_WN * S5_N_NF)/1e-06))+(0.5800000000000001),0) ps=max(2*(((S5_WN * S5_N_NF)/1e-06))+(0.5800000000000001),0)
M5PA (A5 B5 S5 S5) sky130_fd_pr__pfet_g5v0d10v5 w=((S5_WP * S5_P_NF)/1e-06) l=(S5_LP/1e-06) nf=S5_P_NF m=S5_P_M ad=(0.29000000000000004*(((S5_WP * S5_P_NF)/1e-06))) as=(0.29000000000000004*(((S5_WP * S5_P_NF)/1e-06))) pd=max(2*(((S5_WP * S5_P_NF)/1e-06))+(0.5800000000000005),0) ps=max(2*(((S5_WP * S5_P_NF)/1e-06))+(0.5800000000000005),0)
M5PB (B5 A5 S5 S5) sky130_fd_pr__pfet_g5v0d10v5 w=((S5_WP * S5_P_NF)/1e-06) l=(S5_LP/1e-06) nf=S5_P_NF m=S5_P_M ad=(0.29000000000000004*(((S5_WP * S5_P_NF)/1e-06))) as=(0.29000000000000004*(((S5_WP * S5_P_NF)/1e-06))) pd=max(2*(((S5_WP * S5_P_NF)/1e-06))+(0.5800000000000005),0) ps=max(2*(((S5_WP * S5_P_NF)/1e-06))+(0.5800000000000005),0)
C5A (A5 CLKA) capacitor c=S5_CF
C5B (B5 CLKB) capacitor c=S5_CF
C5S (S5 GND) capacitor c=S5_CS
M6NA (A6 B6 S5 S5) sky130_fd_pr__nfet_03v3_nvt w=((S6_WN * S6_N_NF)/1e-06) l=(S6_LN/1e-06) nf=S6_N_NF m=S6_N_M ad=(0.29*(((S6_WN * S6_N_NF)/1e-06))) as=(0.29*(((S6_WN * S6_N_NF)/1e-06))) pd=max(2*(((S6_WN * S6_N_NF)/1e-06))+(0.5800000000000001),0) ps=max(2*(((S6_WN * S6_N_NF)/1e-06))+(0.5800000000000001),0)
M6NB (B6 A6 S5 S5) sky130_fd_pr__nfet_03v3_nvt w=((S6_WN * S6_N_NF)/1e-06) l=(S6_LN/1e-06) nf=S6_N_NF m=S6_N_M ad=(0.29*(((S6_WN * S6_N_NF)/1e-06))) as=(0.29*(((S6_WN * S6_N_NF)/1e-06))) pd=max(2*(((S6_WN * S6_N_NF)/1e-06))+(0.5800000000000001),0) ps=max(2*(((S6_WN * S6_N_NF)/1e-06))+(0.5800000000000001),0)
M6PA (A6 B6 OUT OUT) sky130_fd_pr__pfet_g5v0d10v5 w=((S6_WP * S6_P_NF)/1e-06) l=(S6_LP/1e-06) nf=S6_P_NF m=S6_P_M ad=(0.29*(((S6_WP * S6_P_NF)/1e-06))) as=(0.29*(((S6_WP * S6_P_NF)/1e-06))) pd=max(2*(((S6_WP * S6_P_NF)/1e-06))+(0.5800000000000001),0) ps=max(2*(((S6_WP * S6_P_NF)/1e-06))+(0.5800000000000001),0)
M6PB (B6 A6 OUT OUT) sky130_fd_pr__pfet_g5v0d10v5 w=((S6_WP * S6_P_NF)/1e-06) l=(S6_LP/1e-06) nf=S6_P_NF m=S6_P_M ad=(0.29*(((S6_WP * S6_P_NF)/1e-06))) as=(0.29*(((S6_WP * S6_P_NF)/1e-06))) pd=max(2*(((S6_WP * S6_P_NF)/1e-06))+(0.5800000000000001),0) ps=max(2*(((S6_WP * S6_P_NF)/1e-06))+(0.5800000000000001),0)
C6A (A6 CLKA) capacitor c=S6_CF
C6B (B6 CLKB) capacitor c=S6_CF
C6S (OUT GND) capacitor c=S6_CS
ends NVM_CP
