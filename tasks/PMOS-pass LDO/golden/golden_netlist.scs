// Golden sizing netlist (curator 2026-10-28): the benchmark DUT subckt with its parameter defaults set to
// the golden design (golden_design.json), taken from the verified run's job NN_T27_S1p00/ldo_line_step_v1.
// The DUT subckt and its parameter values are the same in every job of that run (only the testbench changes).
// Instance line of that run: XDUT (vin b_VSS vref out) ldo24c_conventional_dut C_FF=7.142788169753396e-12 I_BIAS=1.3321781830071586e-07 L_BD=1.35231805924752e-05 L_CS=3.0382984351722227e-06 L_FOL=4.813859522562772e-07 L_IN=1.0296...
// Testbench-level variables (bias sources, operating levels) are in golden_design.json and testbench decks.
// Generated by analogiq from dut_benchmark.scs (sha256 ae2a5e8bf1ed3540).
// Connectivity and device models are unchanged except for the listed transformations:
//   - symbols used but not declared in the netlist made DUT parameters: RESR_VALUE, RPAD, R_FB1, R_FB2
//   - ideal elements kept inside the DUT: IBIAS
//   - M1: junction geometry ad/as/pd/ps rewritten in terms of the bound width (area = Lj*W, perimeter = 2*W + c; Lj and c from the netlist)
//   - M2: junction geometry ad/as/pd/ps rewritten in terms of the bound width (area = Lj*W, perimeter = 2*W + c; Lj and c from the netlist)
//   - loop-break iprobe IPRB_LOOP inserted between net VFB and terminal 1 of M2
//   - M3: junction geometry ad/as/pd/ps rewritten in terms of the bound width (area = Lj*W, perimeter = 2*W + c; Lj and c from the netlist)
//   - M4: junction geometry ad/as/pd/ps rewritten in terms of the bound width (area = Lj*W, perimeter = 2*W + c; Lj and c from the netlist)
//   - M5: junction geometry ad/as/pd/ps rewritten in terms of the bound width (area = Lj*W, perimeter = 2*W + c; Lj and c from the netlist)
//   - M6: junction geometry ad/as/pd/ps rewritten in terms of the bound width (area = Lj*W, perimeter = 2*W + c; Lj and c from the netlist)
//   - M7: junction geometry ad/as/pd/ps rewritten in terms of the bound width (area = Lj*W, perimeter = 2*W + c; Lj and c from the netlist)
//   - M8: junction geometry ad/as/pd/ps rewritten in terms of the bound width (area = Lj*W, perimeter = 2*W + c; Lj and c from the netlist)
//   - M9: junction geometry ad/as/pd/ps rewritten in terms of the bound width (area = Lj*W, perimeter = 2*W + c; Lj and c from the netlist)
//   - M10: junction geometry ad/as/pd/ps rewritten in terms of the bound width (area = Lj*W, perimeter = 2*W + c; Lj and c from the netlist)
//   - M11: junction geometry ad/as/pd/ps rewritten in terms of the bound width (area = Lj*W, perimeter = 2*W + c; Lj and c from the netlist)
//   - M12: junction geometry ad/as/pd/ps rewritten in terms of the bound width (area = Lj*W, perimeter = 2*W + c; Lj and c from the netlist)
//   - M13: junction geometry ad/as/pd/ps rewritten in terms of the bound width (area = Lj*W, perimeter = 2*W + c; Lj and c from the netlist)
//   - MPASS: junction geometry ad/as/pd/ps rewritten in terms of the bound width (area = Lj*W, perimeter = 2*W + c; Lj and c from the netlist)
//   - netlist parameters bound to sizing variables: R_FB1 <- R_FB1, R_FB2 <- R_FB2
//   - widths bound to sizing variables on fold-capable devices are folded symbolically into ceil(W/max) fingers of W/ceil(W/max) (per-device max [1e-05] m): M1, M10, M11, M12, M13, M2, M3, M4, M5, M6, M7, M8, M9, MPASS
subckt ldo24c_conventional_dut (VIN VSS VREF VOUT)
parameters W_IN=2.0926289241618188e-05 L_IN=1.0296745004490989e-06 M_IN=2.0 W_BD=9.876389941498025e-07 L_BD=1.35231805924752e-05 W_TL=1.5355836131301476e-06 L_TL=1.5801062512847394e-05 M_TL=6.0 W_ML=2.7424462706287662e-06 L_ML=2.6439619098981046e-06 W_MS=2.6690976214548323e-06 L_MS=3.2552601338191585e-06 W_NM=1.308235972527795e-06 L_NM=7.059897437360952e-06 W_CS=3.602846628332428e-06 L_CS=3.0382984351722227e-06 W_FOL=1.7524904849146877e-05 L_FOL=4.813859522562772e-07 W_PASS=5.488708512050075e-05 L_PASS=2.3987074675061084e-07 M_PASS=11.0 R_FB1=201692.60038783628 R_FB2=859504.0522391661 C_FF=7.142788169753396e-12 I_BIAS=1.3321781830071586e-07 RPAD=0.2 RESR_VALUE=0.01
M1 (VB1 VREF TAIL VSS) nmos1 w=(W_IN/max(1, W_IN/1e-05)) l=L_IN m=M_IN*max(1, W_IN/1e-05) ad=(6.000000000000001e-07*((W_IN/max(1, W_IN/1e-05)))) as=(6.000000000000001e-07*((W_IN/max(1, W_IN/1e-05)))) pd=max(2*((W_IN/max(1, W_IN/1e-05)))+(1.200000000000002e-06),0) ps=max(2*((W_IN/max(1, W_IN/1e-05)))+(1.200000000000002e-06),0)
IPRB_LOOP (VFB VFB__lp) iprobe
M2 (VB2 VFB__lp TAIL VSS) nmos1 w=(W_IN/max(1, W_IN/1e-05)) l=L_IN m=M_IN*max(1, W_IN/1e-05) ad=(6.000000000000001e-07*((W_IN/max(1, W_IN/1e-05)))) as=(6.000000000000001e-07*((W_IN/max(1, W_IN/1e-05)))) pd=max(2*((W_IN/max(1, W_IN/1e-05)))+(1.200000000000002e-06),0) ps=max(2*((W_IN/max(1, W_IN/1e-05)))+(1.200000000000002e-06),0)
M3 (BIAS BIAS VSS VSS) nmos1 w=(W_BD/max(1, W_BD/1e-05)) l=L_BD m=max(1, W_BD/1e-05) ad=(6.000000000000001e-07*((W_BD/max(1, W_BD/1e-05)))) as=(6.000000000000001e-07*((W_BD/max(1, W_BD/1e-05)))) pd=max(2*((W_BD/max(1, W_BD/1e-05)))+(1.2e-06),0) ps=max(2*((W_BD/max(1, W_BD/1e-05)))+(1.2e-06),0)
M4 (TAIL BIAS VSS VSS) nmos1 w=(W_TL/max(1, W_TL/1e-05)) l=L_TL m=M_TL*max(1, W_TL/1e-05) ad=(6.000000000000001e-07*((W_TL/max(1, W_TL/1e-05)))) as=(6.000000000000001e-07*((W_TL/max(1, W_TL/1e-05)))) pd=max(2*((W_TL/max(1, W_TL/1e-05)))+(1.2e-06),0) ps=max(2*((W_TL/max(1, W_TL/1e-05)))+(1.2e-06),0)
M5 (VB2 VB2 VIN VIN) pmos1 w=(W_ML/max(1, W_ML/1e-05)) l=L_ML m=max(1, W_ML/1e-05) ad=(6e-07*((W_ML/max(1, W_ML/1e-05)))) as=(6e-07*((W_ML/max(1, W_ML/1e-05)))) pd=max(2*((W_ML/max(1, W_ML/1e-05)))+(1.1999999999999995e-06),0) ps=max(2*((W_ML/max(1, W_ML/1e-05)))+(1.1999999999999995e-06),0)
M6 (EAOUT VB2 VIN VIN) pmos1 w=(W_ML/max(1, W_ML/1e-05)) l=L_ML m=max(1, W_ML/1e-05) ad=(6e-07*((W_ML/max(1, W_ML/1e-05)))) as=(6e-07*((W_ML/max(1, W_ML/1e-05)))) pd=max(2*((W_ML/max(1, W_ML/1e-05)))+(1.1999999999999995e-06),0) ps=max(2*((W_ML/max(1, W_ML/1e-05)))+(1.1999999999999995e-06),0)
M7 (VB1 VB1 VIN VIN) pmos1 w=(W_MS/max(1, W_MS/1e-05)) l=L_MS m=max(1, W_MS/1e-05) ad=(6e-07*((W_MS/max(1, W_MS/1e-05)))) as=(6e-07*((W_MS/max(1, W_MS/1e-05)))) pd=max(2*((W_MS/max(1, W_MS/1e-05)))+(1.1999999999999995e-06),0) ps=max(2*((W_MS/max(1, W_MS/1e-05)))+(1.1999999999999995e-06),0)
M8 (MIRROR VB1 VIN VIN) pmos1 w=(W_MS/max(1, W_MS/1e-05)) l=L_MS m=max(1, W_MS/1e-05) ad=(6e-07*((W_MS/max(1, W_MS/1e-05)))) as=(6e-07*((W_MS/max(1, W_MS/1e-05)))) pd=max(2*((W_MS/max(1, W_MS/1e-05)))+(1.1999999999999995e-06),0) ps=max(2*((W_MS/max(1, W_MS/1e-05)))+(1.1999999999999995e-06),0)
M9 (MIRROR MIRROR VSS VSS) nmos1 w=(W_NM/max(1, W_NM/1e-05)) l=L_NM m=max(1, W_NM/1e-05) ad=(6e-07*((W_NM/max(1, W_NM/1e-05)))) as=(6e-07*((W_NM/max(1, W_NM/1e-05)))) pd=max(2*((W_NM/max(1, W_NM/1e-05)))+(1.2000000000000004e-06),0) ps=max(2*((W_NM/max(1, W_NM/1e-05)))+(1.2000000000000004e-06),0)
M10 (EAOUT MIRROR VSS VSS) nmos1 w=(W_NM/max(1, W_NM/1e-05)) l=L_NM m=max(1, W_NM/1e-05) ad=(6e-07*((W_NM/max(1, W_NM/1e-05)))) as=(6e-07*((W_NM/max(1, W_NM/1e-05)))) pd=max(2*((W_NM/max(1, W_NM/1e-05)))+(1.2000000000000004e-06),0) ps=max(2*((W_NM/max(1, W_NM/1e-05)))+(1.2000000000000004e-06),0)
M11 (VBUF VB1 VIN VIN) pmos1 w=(W_CS/max(1, W_CS/1e-05)) l=L_CS m=max(1, W_CS/1e-05) ad=(6e-07*((W_CS/max(1, W_CS/1e-05)))) as=(6e-07*((W_CS/max(1, W_CS/1e-05)))) pd=max(2*((W_CS/max(1, W_CS/1e-05)))+(1.1999999999999995e-06),0) ps=max(2*((W_CS/max(1, W_CS/1e-05)))+(1.1999999999999995e-06),0)
M12 (VSS EAOUT VBUF VIN) pmos1 w=(W_FOL/max(1, W_FOL/1e-05)) l=L_FOL m=max(1, W_FOL/1e-05) ad=(6.000000000000001e-07*((W_FOL/max(1, W_FOL/1e-05)))) as=(6.000000000000001e-07*((W_FOL/max(1, W_FOL/1e-05)))) pd=max(2*((W_FOL/max(1, W_FOL/1e-05)))+(1.1999999999999987e-06),0) ps=max(2*((W_FOL/max(1, W_FOL/1e-05)))+(1.1999999999999987e-06),0)
M13 (VBUF VB2 VIN VIN) pmos1 w=(W_CS/max(1, W_CS/1e-05)) l=L_CS m=max(1, W_CS/1e-05) ad=(6e-07*((W_CS/max(1, W_CS/1e-05)))) as=(6e-07*((W_CS/max(1, W_CS/1e-05)))) pd=max(2*((W_CS/max(1, W_CS/1e-05)))+(1.1999999999999995e-06),0) ps=max(2*((W_CS/max(1, W_CS/1e-05)))+(1.1999999999999995e-06),0)
MPASS (VREG VBUF VIN VIN) pmos1 w=(W_PASS/max(1, W_PASS/1e-05)) l=L_PASS m=M_PASS*max(1, W_PASS/1e-05) ad=(6.000000000000001e-07*((W_PASS/max(1, W_PASS/1e-05)))) as=(6.000000000000001e-07*((W_PASS/max(1, W_PASS/1e-05)))) pd=max(2*((W_PASS/max(1, W_PASS/1e-05)))+(1.200000000000002e-06),0) ps=max(2*((W_PASS/max(1, W_PASS/1e-05)))+(1.200000000000002e-06),0)
IBIAS (VIN BIAS) isource dc=I_BIAS
RFB1 (VREG VFB) gpdk180_polyhres sl=max((R_FB1-35)*0.6e-6/352,0.6e-6) w=0.6u
RFB2 (VFB VSS) gpdk180_polyhres sl=max((R_FB2-35)*0.6e-6/352,0.6e-6) w=0.6u
CFF (VREG VFB) capacitor c=C_FF
RPAD_RC (VREG VMID) gpdk180_m1res sl=15u w=0.3u
RPAD_X (VMID VOUT) resistor r=RPAD
COUT (VOUT ESR_NODE) capacitor c=1u
RESR (ESR_NODE VSS) resistor r=RESR_VALUE
ends ldo24c_conventional_dut
