// dut_benchmark.scs = final.scs + the documented real-component changes (paper_fidelity_2026_10_27); see topology.yaml source.modifications
simulator lang=spectre
include "<PDK_ROOT>/gpdk180/models/spectre/gpdk.scs" section=NN
subckt repaired_core VIN VSS VREF VOUT
M1 (VB1 VREF TAIL VSS) nmos1 w=20u l=1u m=2 ad=12p as=12p pd=41.2u ps=41.2u
M2 (VB2 VFB TAIL VSS) nmos1 w=20u l=1u m=2 ad=12p as=12p pd=41.2u ps=41.2u
M3 (BIAS BIAS VSS VSS) nmos1 w=1u l=20u m=1 ad=600f as=600f pd=3.2u ps=3.2u
M4 (TAIL BIAS VSS VSS) nmos1 w=1u l=20u m=10 ad=600f as=600f pd=3.2u ps=3.2u
M5 (VB2 VB2 VIN VIN) pmos1 w=3u l=3u m=1 ad=1.8p as=1.8p pd=7.2u ps=7.2u
M6 (EAOUT VB2 VIN VIN) pmos1 w=3u l=3u m=1 ad=1.8p as=1.8p pd=7.2u ps=7.2u
M7 (VB1 VB1 VIN VIN) pmos1 w=3u l=3u m=1 ad=1.8p as=1.8p pd=7.2u ps=7.2u
M8 (MIRROR VB1 VIN VIN) pmos1 w=3u l=3u m=1 ad=1.8p as=1.8p pd=7.2u ps=7.2u
M9 (MIRROR MIRROR VSS VSS) nmos1 w=2u l=5u m=1 ad=1.2p as=1.2p pd=5.2u ps=5.2u
M10 (EAOUT MIRROR VSS VSS) nmos1 w=2u l=5u m=1 ad=1.2p as=1.2p pd=5.2u ps=5.2u
M11 (VBUF VB1 VIN VIN) pmos1 w=3u l=3u m=1 ad=1.8p as=1.8p pd=7.2u ps=7.2u
M12 (VSS EAOUT VBUF VIN) pmos1 w=10u l=600n m=1 ad=6p as=6p pd=21.2u ps=21.2u
M13 (VBUF VB2 VIN VIN) pmos1 w=3u l=3u m=1 ad=1.8p as=1.8p pd=7.2u ps=7.2u
MPASS (VREG VBUF VIN VIN) pmos1 w=40u l=180n m=10 ad=24p as=24p pd=81.2u ps=81.2u
IBIAS (VIN BIAS) isource dc=100n
RFB1 (VREG VFB) gpdk180_polyhres sl=max((R_FB1-35)*0.6e-6/352,0.6e-6) w=0.6u
RFB2 (VFB VSS) gpdk180_polyhres sl=max((R_FB2-35)*0.6e-6/352,0.6e-6) w=0.6u
// CFF stays the ideal capacitor of final.scs (topology.yaml source.modifications: the PDK nmoscap was tried and does not reproduce the thesis loop results)
CFF (VREG VFB) capacitor c=C_FF
RPAD_RC (VREG VMID) gpdk180_m1res sl=15u w=0.3u
RPAD_X (VMID VOUT) resistor r=RPAD
COUT (VOUT ESR_NODE) capacitor c=1u
RESR (ESR_NODE VSS) resistor r=RESR_VALUE
ends repaired_core
