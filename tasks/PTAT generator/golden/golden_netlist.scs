// Golden sizing netlist (curator 2026-10-28): the benchmark DUT subckt with its parameter defaults set to
// the golden design (golden_design.json), taken from the verified run's job tt_T27_S1p00/lelo30_ptat_dc_v1.
// The DUT subckt and its parameter values are the same in every job of that run (only the testbench changes).
// Instance line of that run: XDUT (vdd vss lpi lpo iout3 iout2 iout1 iout0 vd1 pwr pwrn) ptat_lelo_dut L_BS=3.063955313976281e-07 L_CAS=2.0108111388826446e-07 L_CLPI=1.0618600810410668e-05 L_CVCP=6.023413125354363e-06 L_LVT=4.635...
// Testbench-level variables (bias sources, operating levels) are in golden_design.json and testbench decks.
// Generated by analogiq from dut_benchmark.scs (sha256 a4e0376244ab22ce).
// Connectivity and device models are unchanged except for the listed transformations:
//   - xca2_M1: junction geometry ad/as/pd/ps rewritten in terms of the bound width (area = Lj*W, perimeter = 2*W + c; Lj and c from the netlist)
//   - xca1_M1: junction geometry ad/as/pd/ps rewritten in terms of the bound width (area = Lj*W, perimeter = 2*W + c; Lj and c from the netlist)
//   - xad6_xnd1_M1: junction geometry ad/as/pd/ps rewritten in terms of the bound width (area = Lj*W, perimeter = 2*W + c; Lj and c from the netlist)
//   - xad6_xnd2_M1: junction geometry ad/as/pd/ps rewritten in terms of the bound width (area = Lj*W, perimeter = 2*W + c; Lj and c from the netlist)
//   - xad6_xba6_M1: junction geometry ad/as/pd/ps rewritten in terms of the bound width (area = Lj*W, perimeter = 2*W + c; Lj and c from the netlist)
//   - xad6_xnd3_M1: junction geometry ad/as/pd/ps rewritten in terms of the bound width (area = Lj*W, perimeter = 2*W + c; Lj and c from the netlist)
//   - xad6_xba8_M1: junction geometry ad/as/pd/ps rewritten in terms of the bound width (area = Lj*W, perimeter = 2*W + c; Lj and c from the netlist)
//   - xad6_xnd4_M1: junction geometry ad/as/pd/ps rewritten in terms of the bound width (area = Lj*W, perimeter = 2*W + c; Lj and c from the netlist)
//   - xad6_xnc0_M1: junction geometry ad/as/pd/ps rewritten in terms of the bound width (area = Lj*W, perimeter = 2*W + c; Lj and c from the netlist)
//   - xad6_xnc1_M1: junction geometry ad/as/pd/ps rewritten in terms of the bound width (area = Lj*W, perimeter = 2*W + c; Lj and c from the netlist)
//   - xad6_xbs6_M1: junction geometry ad/as/pd/ps rewritten in terms of the bound width (area = Lj*W, perimeter = 2*W + c; Lj and c from the netlist)
//   - xad6_xbs1_M1: junction geometry ad/as/pd/ps rewritten in terms of the bound width (area = Lj*W, perimeter = 2*W + c; Lj and c from the netlist)
//   - xad6_xbs2_M1: junction geometry ad/as/pd/ps rewritten in terms of the bound width (area = Lj*W, perimeter = 2*W + c; Lj and c from the netlist)
//   - xad6_xbs4_M1: junction geometry ad/as/pd/ps rewritten in terms of the bound width (area = Lj*W, perimeter = 2*W + c; Lj and c from the netlist)
//   - xad6_xbs7_M1: junction geometry ad/as/pd/ps rewritten in terms of the bound width (area = Lj*W, perimeter = 2*W + c; Lj and c from the netlist)
//   - xad6_xbs8_M1: junction geometry ad/as/pd/ps rewritten in terms of the bound width (area = Lj*W, perimeter = 2*W + c; Lj and c from the netlist)
//   - xad6_xbl1_M1: junction geometry ad/as/pd/ps rewritten in terms of the bound width (area = Lj*W, perimeter = 2*W + c; Lj and c from the netlist)
//   - xad6_xbl2_M1: junction geometry ad/as/pd/ps rewritten in terms of the bound width (area = Lj*W, perimeter = 2*W + c; Lj and c from the netlist)
//   - xad6_xbl4_M1: junction geometry ad/as/pd/ps rewritten in terms of the bound width (area = Lj*W, perimeter = 2*W + c; Lj and c from the netlist)
//   - xad6_xbl5_M1: junction geometry ad/as/pd/ps rewritten in terms of the bound width (area = Lj*W, perimeter = 2*W + c; Lj and c from the netlist)
//   - xca3_3__M1: junction geometry ad/as/pd/ps rewritten in terms of the bound width (area = Lj*W, perimeter = 2*W + c; Lj and c from the netlist)
//   - xca3_2__M1: junction geometry ad/as/pd/ps rewritten in terms of the bound width (area = Lj*W, perimeter = 2*W + c; Lj and c from the netlist)
//   - xca3_1__M1: junction geometry ad/as/pd/ps rewritten in terms of the bound width (area = Lj*W, perimeter = 2*W + c; Lj and c from the netlist)
//   - xca3_0__M1: junction geometry ad/as/pd/ps rewritten in terms of the bound width (area = Lj*W, perimeter = 2*W + c; Lj and c from the netlist)
//   - xca2_3__M1: junction geometry ad/as/pd/ps rewritten in terms of the bound width (area = Lj*W, perimeter = 2*W + c; Lj and c from the netlist)
//   - xca2_2__M1: junction geometry ad/as/pd/ps rewritten in terms of the bound width (area = Lj*W, perimeter = 2*W + c; Lj and c from the netlist)
//   - xca2_1__M1: junction geometry ad/as/pd/ps rewritten in terms of the bound width (area = Lj*W, perimeter = 2*W + c; Lj and c from the netlist)
//   - xca2_0__M1: junction geometry ad/as/pd/ps rewritten in terms of the bound width (area = Lj*W, perimeter = 2*W + c; Lj and c from the netlist)
//   - xca4_M1: junction geometry ad/as/pd/ps rewritten in terms of the bound width (area = Lj*W, perimeter = 2*W + c; Lj and c from the netlist)
//   - xca5_M1: junction geometry ad/as/pd/ps rewritten in terms of the bound width (area = Lj*W, perimeter = 2*W + c; Lj and c from the netlist)
//   - netlist parameters bound to sizing variables: W_BS <- W_BS, W_CAS <- W_CAS, W_LVT <- W_LVT, W_MIR <- W_MIR, W_NCR <- W_NCR, W_NLD <- W_NLD, W_PMIR <- W_PMIR
subckt ptat_lelo_dut (VDD_1V8 VSS LPI LPO IBP_1U_3 IBP_1U_2 IBP_1U_1 IBP_1U_0 VD1 PWRUP_1V8 PWRUP_N_1V8)
parameters W_MIR=9.721782405901073e-07 L_MIR=1.1601741741962385e-06 NF_MIR=8.0 W_CAS=2.244724928379297e-06 L_CAS=2.0108111388826446e-07 NF_CAS=1.0 W_NLD=1.0208576586507258e-06 L_NLD=7.819094045163309e-07 NF_NLD=9.0 W_PMIR=1.209150755442009e-06 L_PMIR=7.72056379120699e-07 NF_PMIR=10.0 W_LVT=2.8673064205451517e-06 L_LVT=4.635868695738736e-07 NF_LVT=5.0 W_NCR=2.2611059245277288e-06 L_NCR=1.2985878420624567e-06 NF_NCR=11.0 W_BS=1.4735030951244682e-06 L_BS=3.063955313976281e-07 NF_BS=4.0 W_RLAD=3.6008661289238403e-07 L_RLAD=7.601199079107036e-06 W_RTAIL=4.232915026496513e-07 L_RTAIL=1.0420051878013265e-05 W_CLPI=2.91979474928115e-06 L_CLPI=1.0618600810410668e-05 W_CVCP=3.3801210427163556e-06 L_CVCP=6.023413125354363e-06
xca2_M1 (VBD2 LPI VDD_1V8 VDD_1V8) sky130_fd_pr__pfet_01v8 w=((W_MIR*NF_MIR)/1e-06) l=(L_MIR/1e-06) nf=NF_MIR mult=1.0 ad=(0.145*(((W_MIR*NF_MIR)/1e-06))) as=(0.29*(((W_MIR*NF_MIR)/1e-06))) pd=max(2*(((W_MIR*NF_MIR)/1e-06))+(-2.6200000000000006),0) ps=max(2*(((W_MIR*NF_MIR)/1e-06))+(1.1599999999999993),0) sa=0 sb=0 sd=0 m=1.0
xca1_M1 (VBD1 LPI VDD_1V8 VDD_1V8) sky130_fd_pr__pfet_01v8 w=((W_MIR*NF_MIR)/1e-06) l=(L_MIR/1e-06) nf=NF_MIR mult=8.0 ad=(0.145*(((W_MIR*NF_MIR)/1e-06))) as=(0.29*(((W_MIR*NF_MIR)/1e-06))) pd=max(2*(((W_MIR*NF_MIR)/1e-06))+(-2.6200000000000006),0) ps=max(2*(((W_MIR*NF_MIR)/1e-06))+(1.1599999999999993),0) sa=0 sb=0 sd=0 m=8.0
xd1_C1 (VDD_1V8 LPI) sky130_fd_pr__cap_mim_m3_1 w=(W_CLPI/1e-06) l=(L_CLPI/1e-06) mult=10.0 m=10.0
xad6_xnd1_M1 (xad6_VD1 xad6_VD1 VSS VSS) sky130_fd_pr__nfet_01v8 w=((W_NLD*NF_NLD)/1e-06) l=(L_NLD/1e-06) nf=NF_NLD mult=4.0 ad=(0.145*(((W_NLD*NF_NLD)/1e-06))) as=(0.29*(((W_NLD*NF_NLD)/1e-06))) pd=max(2*(((W_NLD*NF_NLD)/1e-06))+(-2.6200000000000006),0) ps=max(2*(((W_NLD*NF_NLD)/1e-06))+(1.1599999999999993),0) sa=0 sb=0 sd=0 m=4.0
xad6_xnd2_M1 (xad6_VD2 xad6_VD2 VSS VSS) sky130_fd_pr__nfet_01v8 w=((W_NLD*NF_NLD)/1e-06) l=(L_NLD/1e-06) nf=NF_NLD mult=4.0 ad=(0.145*(((W_NLD*NF_NLD)/1e-06))) as=(0.29*(((W_NLD*NF_NLD)/1e-06))) pd=max(2*(((W_NLD*NF_NLD)/1e-06))+(-2.6200000000000006),0) ps=max(2*(((W_NLD*NF_NLD)/1e-06))+(1.1599999999999993),0) sa=0 sb=0 sd=0 m=4.0
xad6_xba6_M1 (xad6_VBP xad6_VBP VDD_1V8 VDD_1V8) sky130_fd_pr__pfet_01v8 w=((W_PMIR*NF_PMIR)/1e-06) l=(L_PMIR/1e-06) nf=NF_PMIR mult=1.0 ad=(0.145*(((W_PMIR*NF_PMIR)/1e-06))) as=(0.29*(((W_PMIR*NF_PMIR)/1e-06))) pd=max(2*(((W_PMIR*NF_PMIR)/1e-06))+(-7.1),0) ps=max(2*(((W_PMIR*NF_PMIR)/1e-06))+(1.1600000000000001),0) sa=0 sb=0 sd=0 m=1.0
xad6_xnd3_M1 (xad6_VBP xad6_VD1 VSS VSS) sky130_fd_pr__nfet_01v8 w=((W_NLD*NF_NLD)/1e-06) l=(L_NLD/1e-06) nf=NF_NLD mult=1.0 ad=(0.145*(((W_NLD*NF_NLD)/1e-06))) as=(0.29*(((W_NLD*NF_NLD)/1e-06))) pd=max(2*(((W_NLD*NF_NLD)/1e-06))+(-2.6200000000000006),0) ps=max(2*(((W_NLD*NF_NLD)/1e-06))+(1.1599999999999993),0) sa=0 sb=0 sd=0 m=1.0
xad6_xba8_M1 (LPO xad6_VBP VDD_1V8 VDD_1V8) sky130_fd_pr__pfet_01v8 w=((W_PMIR*NF_PMIR)/1e-06) l=(L_PMIR/1e-06) nf=NF_PMIR mult=1.0 ad=(0.145*(((W_PMIR*NF_PMIR)/1e-06))) as=(0.29*(((W_PMIR*NF_PMIR)/1e-06))) pd=max(2*(((W_PMIR*NF_PMIR)/1e-06))+(-7.1),0) ps=max(2*(((W_PMIR*NF_PMIR)/1e-06))+(1.1600000000000001),0) sa=0 sb=0 sd=0 m=1.0
xad6_xnd4_M1 (LPO xad6_VD2 VSS VSS) sky130_fd_pr__nfet_01v8 w=((W_NLD*NF_NLD)/1e-06) l=(L_NLD/1e-06) nf=NF_NLD mult=1.0 ad=(0.145*(((W_NLD*NF_NLD)/1e-06))) as=(0.29*(((W_NLD*NF_NLD)/1e-06))) pd=max(2*(((W_NLD*NF_NLD)/1e-06))+(-2.6200000000000006),0) ps=max(2*(((W_NLD*NF_NLD)/1e-06))+(1.1599999999999993),0) sa=0 sb=0 sd=0 m=1.0
xad6_xd2_1__R1_0 (xad6_xd2_1__INT_0 xad6_VDS VSS) sky130_fd_pr__res_high_po w=(W_RTAIL/1e-06) l=(L_RTAIL/1e-06) mult=1.0 m=1.0
xad6_xd2_1__R1_1 (xad6_R1_0 xad6_xd2_1__INT_0 VSS) sky130_fd_pr__res_high_po w=(W_RTAIL/1e-06) l=(L_RTAIL/1e-06) mult=1.0 m=1.0
xad6_xd2_0__R1_0 (xad6_xd2_0__INT_0 xad6_R1_0 VSS) sky130_fd_pr__res_high_po w=(W_RTAIL/1e-06) l=(L_RTAIL/1e-06) mult=1.0 m=1.0
xad6_xd2_0__R1_1 (xad6_VS xad6_xd2_0__INT_0 VSS) sky130_fd_pr__res_high_po w=(W_RTAIL/1e-06) l=(L_RTAIL/1e-06) mult=1.0 m=1.0
xad6_xba7_M1 (xad6_VBP PWRUP_1V8 VDD_1V8 VDD_1V8) sky130_fd_pr__pfet_01v8 w=7.68 l=0.94 nf=2 mult=1.0 ad=1.1136 as=2.2272 pd=8.26 ps=16.52 sa=0 sb=0 sd=0 m=1.0
xad6_xba1_M1 (xad6_VDS PWRUP_N_1V8 VDD_1V8 VDD_1V8) sky130_fd_pr__pfet_01v8 w=7.68 l=0.94 nf=2 mult=1.0 ad=1.1136 as=2.2272 pd=8.26 ps=16.52 sa=0 sb=0 sd=0 m=1.0
xad6_xba2_M1 (LPO PWRUP_1V8 VDD_1V8 VDD_1V8) sky130_fd_pr__pfet_01v8 w=7.68 l=0.94 nf=2 mult=1.0 ad=1.1136 as=2.2272 pd=8.26 ps=16.52 sa=0 sb=0 sd=0 m=1.0
xad6_xns1_M1 (xad6_VD1 PWRUP_N_1V8 VSS VSS) sky130_fd_pr__nfet_01v8 w=3.2 l=0.94 nf=2 mult=1.0 ad=0.464 as=0.928 pd=3.78 ps=7.56 sa=0 sb=0 sd=0 m=1.0
xad6_xns2_M1 (xad6_VD2 PWRUP_N_1V8 VSS VSS) sky130_fd_pr__nfet_01v8 w=3.2 l=0.94 nf=2 mult=1.0 ad=0.464 as=0.928 pd=3.78 ps=7.56 sa=0 sb=0 sd=0 m=1.0
xad6_xnc0_M1 (xad6_VD3 xad6_VD3 VSS VSS) sky130_fd_pr__nfet_01v8 w=((W_NCR*NF_NCR)/1e-06) l=(L_NCR/1e-06) nf=NF_NCR mult=1.0 ad=(0.145*(((W_NCR*NF_NCR)/1e-06))) as=(0.29*(((W_NCR*NF_NCR)/1e-06))) pd=max(2*(((W_NCR*NF_NCR)/1e-06))+(-2.6200000000000006),0) ps=max(2*(((W_NCR*NF_NCR)/1e-06))+(1.1599999999999993),0) sa=0 sb=0 sd=0 m=1.0
xad6_xnc1_M1 (VCP xad6_VD3 VSS VSS) sky130_fd_pr__nfet_01v8 w=((W_NCR*NF_NCR)/1e-06) l=(L_NCR/1e-06) nf=NF_NCR mult=3.0 ad=(0.145*(((W_NCR*NF_NCR)/1e-06))) as=(0.29*(((W_NCR*NF_NCR)/1e-06))) pd=max(2*(((W_NCR*NF_NCR)/1e-06))+(-2.6200000000000006),0) ps=max(2*(((W_NCR*NF_NCR)/1e-06))+(1.1599999999999993),0) sa=0 sb=0 sd=0 m=3.0
xad6_xbs6_M1 (xad6__net1 VCP VDD_1V8 VDD_1V8) sky130_fd_pr__pfet_01v8 w=((W_BS*NF_BS)/1e-06) l=(L_BS/1e-06) nf=NF_BS mult=1.0 ad=(0.145*(((W_BS*NF_BS)/1e-06))) as=(0.29*(((W_BS*NF_BS)/1e-06))) pd=max(2*(((W_BS*NF_BS)/1e-06))+(-2.6200000000000006),0) ps=max(2*(((W_BS*NF_BS)/1e-06))+(1.1599999999999993),0) sa=0 sb=0 sd=0 m=1.0
xad6_xbs1_M1 (xad6__net2 VCP xad6__net1 VDD_1V8) sky130_fd_pr__pfet_01v8 w=((W_BS*NF_BS)/1e-06) l=(L_BS/1e-06) nf=NF_BS mult=1.0 ad=(0.145*(((W_BS*NF_BS)/1e-06))) as=(0.29*(((W_BS*NF_BS)/1e-06))) pd=max(2*(((W_BS*NF_BS)/1e-06))+(-2.6200000000000006),0) ps=max(2*(((W_BS*NF_BS)/1e-06))+(1.1599999999999993),0) sa=0 sb=0 sd=0 m=1.0
xad6_xbs2_M1 (xad6__net4 VCP xad6__net2 VDD_1V8) sky130_fd_pr__pfet_01v8 w=((W_BS*NF_BS)/1e-06) l=(L_BS/1e-06) nf=NF_BS mult=1.0 ad=(0.145*(((W_BS*NF_BS)/1e-06))) as=(0.29*(((W_BS*NF_BS)/1e-06))) pd=max(2*(((W_BS*NF_BS)/1e-06))+(-2.6200000000000006),0) ps=max(2*(((W_BS*NF_BS)/1e-06))+(1.1599999999999993),0) sa=0 sb=0 sd=0 m=1.0
xad6_xbs4_M1 (xad6__net3 VCP xad6__net4 VDD_1V8) sky130_fd_pr__pfet_01v8 w=((W_BS*NF_BS)/1e-06) l=(L_BS/1e-06) nf=NF_BS mult=1.0 ad=(0.145*(((W_BS*NF_BS)/1e-06))) as=(0.29*(((W_BS*NF_BS)/1e-06))) pd=max(2*(((W_BS*NF_BS)/1e-06))+(-2.6200000000000006),0) ps=max(2*(((W_BS*NF_BS)/1e-06))+(1.1599999999999993),0) sa=0 sb=0 sd=0 m=1.0
xad6_xbs7_M1 (xad6__net5 VCP xad6__net3 VDD_1V8) sky130_fd_pr__pfet_01v8 w=((W_BS*NF_BS)/1e-06) l=(L_BS/1e-06) nf=NF_BS mult=1.0 ad=(0.145*(((W_BS*NF_BS)/1e-06))) as=(0.29*(((W_BS*NF_BS)/1e-06))) pd=max(2*(((W_BS*NF_BS)/1e-06))+(-2.6200000000000006),0) ps=max(2*(((W_BS*NF_BS)/1e-06))+(1.1599999999999993),0) sa=0 sb=0 sd=0 m=1.0
xad6_xns4_M1 (xad6_VD3 PWRUP_N_1V8 VSS VSS) sky130_fd_pr__nfet_01v8 w=3.2 l=0.94 nf=2 mult=1.0 ad=0.464 as=0.928 pd=3.78 ps=7.56 sa=0 sb=0 sd=0 m=1.0
xad6_xba3_M1 (VCP PWRUP_1V8 VDD_1V8 VDD_1V8) sky130_fd_pr__pfet_01v8 w=7.68 l=0.94 nf=2 mult=1.0 ad=1.1136 as=2.2272 pd=8.26 ps=16.52 sa=0 sb=0 sd=0 m=1.0
xad6_xbs8_M1 (VCP VCP xad6__net5 VDD_1V8) sky130_fd_pr__pfet_01v8 w=((W_BS*NF_BS)/1e-06) l=(L_BS/1e-06) nf=NF_BS mult=1.0 ad=(0.145*(((W_BS*NF_BS)/1e-06))) as=(0.29*(((W_BS*NF_BS)/1e-06))) pd=max(2*(((W_BS*NF_BS)/1e-06))+(-2.6200000000000006),0) ps=max(2*(((W_BS*NF_BS)/1e-06))+(1.1599999999999993),0) sa=0 sb=0 sd=0 m=1.0
xad6_xbl1_M1 (xad6_VD1 VD1 xad6_VS VDD_1V8) sky130_fd_pr__pfet_01v8_lvt w=((W_LVT*NF_LVT)/1e-06) l=(L_LVT/1e-06) nf=NF_LVT mult=4.0 ad=(0.145*(((W_LVT*NF_LVT)/1e-06))) as=(0.29*(((W_LVT*NF_LVT)/1e-06))) pd=max(2*(((W_LVT*NF_LVT)/1e-06))+(-7.1),0) ps=max(2*(((W_LVT*NF_LVT)/1e-06))+(1.1600000000000001),0) sa=0 sb=0 sd=0 m=4.0
xad6_xbl2_M1 (xad6_VD2 VR1 xad6_VS VDD_1V8) sky130_fd_pr__pfet_01v8_lvt w=((W_LVT*NF_LVT)/1e-06) l=(L_LVT/1e-06) nf=NF_LVT mult=4.0 ad=(0.145*(((W_LVT*NF_LVT)/1e-06))) as=(0.29*(((W_LVT*NF_LVT)/1e-06))) pd=max(2*(((W_LVT*NF_LVT)/1e-06))+(-7.1),0) ps=max(2*(((W_LVT*NF_LVT)/1e-06))+(1.1600000000000001),0) sa=0 sb=0 sd=0 m=4.0
xad6_xbl4_M1 (xad6_VD3 VD1 xad6_VS VDD_1V8) sky130_fd_pr__pfet_01v8_lvt w=((W_LVT*NF_LVT)/1e-06) l=(L_LVT/1e-06) nf=NF_LVT mult=1.0 ad=(0.145*(((W_LVT*NF_LVT)/1e-06))) as=(0.29*(((W_LVT*NF_LVT)/1e-06))) pd=max(2*(((W_LVT*NF_LVT)/1e-06))+(-7.1),0) ps=max(2*(((W_LVT*NF_LVT)/1e-06))+(1.1600000000000001),0) sa=0 sb=0 sd=0 m=1.0
xad6_xbl5_M1 (xad6_VD3 VR1 xad6_VS VDD_1V8) sky130_fd_pr__pfet_01v8_lvt w=((W_LVT*NF_LVT)/1e-06) l=(L_LVT/1e-06) nf=NF_LVT mult=1.0 ad=(0.145*(((W_LVT*NF_LVT)/1e-06))) as=(0.29*(((W_LVT*NF_LVT)/1e-06))) pd=max(2*(((W_LVT*NF_LVT)/1e-06))+(-7.1),0) ps=max(2*(((W_LVT*NF_LVT)/1e-06))+(1.1600000000000001),0) sa=0 sb=0 sd=0 m=1.0
xad6_xfill_p_in_a_0_M1 (VDD_1V8 VDD_1V8 VDD_1V8 VDD_1V8) sky130_fd_pr__pfet_01v8_lvt w=7.68 l=0.94 nf=2 mult=1.0 ad=1.1136 as=2.2272 pd=8.26 ps=16.52 sa=0 sb=0 sd=0 m=1.0
xad6_xfill_p_in_b_0_M1 (VDD_1V8 VDD_1V8 VDD_1V8 VDD_1V8) sky130_fd_pr__pfet_01v8_lvt w=7.68 l=0.94 nf=2 mult=1.0 ad=1.1136 as=2.2272 pd=8.26 ps=16.52 sa=0 sb=0 sd=0 m=1.0
xad6_xfill_n_mirr_0_M1 (VSS VSS VSS VSS) sky130_fd_pr__nfet_01v8 w=3.2 l=0.94 nf=2 mult=1.0 ad=0.464 as=0.928 pd=3.78 ps=7.56 sa=0 sb=0 sd=0 m=1.0
xca3_3__M1 (IBD_3 LPI VDD_1V8 VDD_1V8) sky130_fd_pr__pfet_01v8 w=((W_MIR*NF_MIR)/1e-06) l=(L_MIR/1e-06) nf=NF_MIR mult=1.0 ad=(0.145*(((W_MIR*NF_MIR)/1e-06))) as=(0.29*(((W_MIR*NF_MIR)/1e-06))) pd=max(2*(((W_MIR*NF_MIR)/1e-06))+(-2.6200000000000006),0) ps=max(2*(((W_MIR*NF_MIR)/1e-06))+(1.1599999999999993),0) sa=0 sb=0 sd=0 m=1.0
xca3_2__M1 (IBD_2 LPI VDD_1V8 VDD_1V8) sky130_fd_pr__pfet_01v8 w=((W_MIR*NF_MIR)/1e-06) l=(L_MIR/1e-06) nf=NF_MIR mult=1.0 ad=(0.145*(((W_MIR*NF_MIR)/1e-06))) as=(0.29*(((W_MIR*NF_MIR)/1e-06))) pd=max(2*(((W_MIR*NF_MIR)/1e-06))+(-2.6200000000000006),0) ps=max(2*(((W_MIR*NF_MIR)/1e-06))+(1.1599999999999993),0) sa=0 sb=0 sd=0 m=1.0
xca3_1__M1 (IBD_1 LPI VDD_1V8 VDD_1V8) sky130_fd_pr__pfet_01v8 w=((W_MIR*NF_MIR)/1e-06) l=(L_MIR/1e-06) nf=NF_MIR mult=1.0 ad=(0.145*(((W_MIR*NF_MIR)/1e-06))) as=(0.29*(((W_MIR*NF_MIR)/1e-06))) pd=max(2*(((W_MIR*NF_MIR)/1e-06))+(-2.6200000000000006),0) ps=max(2*(((W_MIR*NF_MIR)/1e-06))+(1.1599999999999993),0) sa=0 sb=0 sd=0 m=1.0
xca3_0__M1 (IBD_0 LPI VDD_1V8 VDD_1V8) sky130_fd_pr__pfet_01v8 w=((W_MIR*NF_MIR)/1e-06) l=(L_MIR/1e-06) nf=NF_MIR mult=1.0 ad=(0.145*(((W_MIR*NF_MIR)/1e-06))) as=(0.29*(((W_MIR*NF_MIR)/1e-06))) pd=max(2*(((W_MIR*NF_MIR)/1e-06))+(-2.6200000000000006),0) ps=max(2*(((W_MIR*NF_MIR)/1e-06))+(1.1599999999999993),0) sa=0 sb=0 sd=0 m=1.0
xe1_Q1 (VSS VSS VD1) sky130_fd_pr__pnp_05v5_W3p40L3p40 mult=1.0 m=1.0
xe1_Q2 (VSS VSS VD2) sky130_fd_pr__pnp_05v5_W3p40L3p40 mult=8.0 m=8.0
xg1_M1 (VR1 VR1 VD2 VSS) sky130_fd_pr__nfet_01v8 w=3.2 l=0.94 nf=2 mult=1.0 ad=0.464 as=0.928 pd=3.78 ps=7.56 sa=0 sb=0 sd=0 m=1.0
xcc_M1 (VDD_1V8 VDD_1V8 VDD_1V8 VDD_1V8) sky130_fd_pr__pfet_01v8 w=3.2 l=0.94 nf=2 mult=5.0 ad=0.464 as=0.928 pd=3.78 ps=7.56 sa=0 sb=0 sd=0 m=5.0
xca2_3__M1 (IBP_1U_3 VCP IBD_3 VDD_1V8) sky130_fd_pr__pfet_01v8 w=((W_CAS*NF_CAS)/1e-06) l=(L_CAS/1e-06) nf=NF_CAS mult=1.0 ad=(0.145*(((W_CAS*NF_CAS)/1e-06))) as=(0.29*(((W_CAS*NF_CAS)/1e-06))) pd=max(2*(((W_CAS*NF_CAS)/1e-06))+(-2.6200000000000006),0) ps=max(2*(((W_CAS*NF_CAS)/1e-06))+(1.1599999999999993),0) sa=0 sb=0 sd=0 m=1.0
xca2_2__M1 (IBP_1U_2 VCP IBD_2 VDD_1V8) sky130_fd_pr__pfet_01v8 w=((W_CAS*NF_CAS)/1e-06) l=(L_CAS/1e-06) nf=NF_CAS mult=1.0 ad=(0.145*(((W_CAS*NF_CAS)/1e-06))) as=(0.29*(((W_CAS*NF_CAS)/1e-06))) pd=max(2*(((W_CAS*NF_CAS)/1e-06))+(-2.6200000000000006),0) ps=max(2*(((W_CAS*NF_CAS)/1e-06))+(1.1599999999999993),0) sa=0 sb=0 sd=0 m=1.0
xca2_1__M1 (IBP_1U_1 VCP IBD_1 VDD_1V8) sky130_fd_pr__pfet_01v8 w=((W_CAS*NF_CAS)/1e-06) l=(L_CAS/1e-06) nf=NF_CAS mult=1.0 ad=(0.145*(((W_CAS*NF_CAS)/1e-06))) as=(0.29*(((W_CAS*NF_CAS)/1e-06))) pd=max(2*(((W_CAS*NF_CAS)/1e-06))+(-2.6200000000000006),0) ps=max(2*(((W_CAS*NF_CAS)/1e-06))+(1.1599999999999993),0) sa=0 sb=0 sd=0 m=1.0
xca2_0__M1 (IBP_1U_0 VCP IBD_0 VDD_1V8) sky130_fd_pr__pfet_01v8 w=((W_CAS*NF_CAS)/1e-06) l=(L_CAS/1e-06) nf=NF_CAS mult=1.0 ad=(0.145*(((W_CAS*NF_CAS)/1e-06))) as=(0.29*(((W_CAS*NF_CAS)/1e-06))) pd=max(2*(((W_CAS*NF_CAS)/1e-06))+(-2.6200000000000006),0) ps=max(2*(((W_CAS*NF_CAS)/1e-06))+(1.1599999999999993),0) sa=0 sb=0 sd=0 m=1.0
xca4_M1 (VR1 VCP VBD2 VDD_1V8) sky130_fd_pr__pfet_01v8 w=((W_CAS*NF_CAS)/1e-06) l=(L_CAS/1e-06) nf=NF_CAS mult=1.0 ad=(0.145*(((W_CAS*NF_CAS)/1e-06))) as=(0.29*(((W_CAS*NF_CAS)/1e-06))) pd=max(2*(((W_CAS*NF_CAS)/1e-06))+(-2.6200000000000006),0) ps=max(2*(((W_CAS*NF_CAS)/1e-06))+(1.1599999999999993),0) sa=0 sb=0 sd=0 m=1.0
xca5_M1 (VD1 VCP VBD1 VDD_1V8) sky130_fd_pr__pfet_01v8 w=((W_CAS*NF_CAS)/1e-06) l=(L_CAS/1e-06) nf=NF_CAS mult=8.0 ad=(0.145*(((W_CAS*NF_CAS)/1e-06))) as=(0.29*(((W_CAS*NF_CAS)/1e-06))) pd=max(2*(((W_CAS*NF_CAS)/1e-06))+(-2.6200000000000006),0) ps=max(2*(((W_CAS*NF_CAS)/1e-06))+(1.1599999999999993),0) sa=0 sb=0 sd=0 m=8.0
xd2_C1 (VDD_1V8 VCP) sky130_fd_pr__cap_mim_m3_1 w=(W_CVCP/1e-06) l=(L_CVCP/1e-06) mult=3.0 m=3.0
xsu1_M1 (VSU VSU VDD_1V8 VDD_1V8) sky130_fd_pr__pfet_01v8 w=1.92 l=0.94 nf=2 mult=1.0 ad=0.2784 as=0.5568 pd=2.5 ps=5 sa=0 sb=0 sd=0 m=1.0
xsu2_M1 (VD1 VD1 VSU VDD_1V8) sky130_fd_pr__pfet_01v8 w=1.92 l=0.94 nf=2 mult=1.0 ad=0.2784 as=0.5568 pd=2.5 ps=5 sa=0 sb=0 sd=0 m=1.0
xd3_5__R1_0 (xd3_5__INT_0 VR1 VSS) sky130_fd_pr__res_high_po w=(W_RLAD/1e-06) l=(L_RLAD/1e-06) mult=1.0 m=1.0
xd3_5__R1_1 (R1_4 xd3_5__INT_0 VSS) sky130_fd_pr__res_high_po w=(W_RLAD/1e-06) l=(L_RLAD/1e-06) mult=1.0 m=1.0
xd3_4__R1_0 (xd3_4__INT_0 R1_4 VSS) sky130_fd_pr__res_high_po w=(W_RLAD/1e-06) l=(L_RLAD/1e-06) mult=1.0 m=1.0
xd3_4__R1_1 (R1_3 xd3_4__INT_0 VSS) sky130_fd_pr__res_high_po w=(W_RLAD/1e-06) l=(L_RLAD/1e-06) mult=1.0 m=1.0
xd3_3__R1_0 (xd3_3__INT_0 R1_3 VSS) sky130_fd_pr__res_high_po w=(W_RLAD/1e-06) l=(L_RLAD/1e-06) mult=1.0 m=1.0
xd3_3__R1_1 (R1_2 xd3_3__INT_0 VSS) sky130_fd_pr__res_high_po w=(W_RLAD/1e-06) l=(L_RLAD/1e-06) mult=1.0 m=1.0
xd3_2__R1_0 (xd3_2__INT_0 R1_2 VSS) sky130_fd_pr__res_high_po w=(W_RLAD/1e-06) l=(L_RLAD/1e-06) mult=1.0 m=1.0
xd3_2__R1_1 (R1_1 xd3_2__INT_0 VSS) sky130_fd_pr__res_high_po w=(W_RLAD/1e-06) l=(L_RLAD/1e-06) mult=1.0 m=1.0
xd3_1__R1_0 (xd3_1__INT_0 R1_1 VSS) sky130_fd_pr__res_high_po w=(W_RLAD/1e-06) l=(L_RLAD/1e-06) mult=1.0 m=1.0
xd3_1__R1_1 (R1_0 xd3_1__INT_0 VSS) sky130_fd_pr__res_high_po w=(W_RLAD/1e-06) l=(L_RLAD/1e-06) mult=1.0 m=1.0
xd3_0__R1_0 (xd3_0__INT_0 R1_0 VSS) sky130_fd_pr__res_high_po w=(W_RLAD/1e-06) l=(L_RLAD/1e-06) mult=1.0 m=1.0
xd3_0__R1_1 (VD2 xd3_0__INT_0 VSS) sky130_fd_pr__res_high_po w=(W_RLAD/1e-06) l=(L_RLAD/1e-06) mult=1.0 m=1.0
xfill_p_su_M1 (VDD_1V8 VDD_1V8 VDD_1V8 VDD_1V8) sky130_fd_pr__pfet_01v8 w=1.92 l=0.94 nf=2 mult=11.0 ad=0.2784 as=0.5568 pd=2.5 ps=5 sa=0 sb=0 sd=0 m=11.0
xfill_p_cc_M1 (VDD_1V8 VDD_1V8 VDD_1V8 VDD_1V8) sky130_fd_pr__pfet_01v8 w=3.2 l=0.94 nf=2 mult=8.0 ad=0.464 as=0.928 pd=3.78 ps=7.56 sa=0 sb=0 sd=0 m=8.0
ends ptat_lelo_dut
