// Golden sizing netlist (curator 2026-10-28): the benchmark DUT subckt with its parameter defaults set to
// the golden design (golden_design.json), taken from the verified run's job NN_T27_S1p00/osc_pnoise_se_v1.
// The DUT subckt and its parameter values are the same in every job of that run (only the testbench changes).
// Instance line of that run: XDUT (vdd b_VSS b_VBP b_VBN outp) repaired_core C_LOAD=2.2333992836044953e-14 L_HSW=1.2251676722594025e-06 L_LHD=7.240568194703897e-07 L_LLD=2.4919711216528e-06 L_LSW=8.149822520588248e-07 L_NI=3.1349...
// Testbench-level variables (bias sources, operating levels) are in golden_design.json and testbench decks.
// Generated by analogiq from final.scs (sha256 51cdc89ccb539fbc).
// Connectivity and device models are unchanged except for the listed transformations:
//   - MP2: junction geometry ad/as/pd/ps rewritten in terms of the bound width (area = Lj*W, perimeter = 2*W + c; Lj and c from the netlist)
//   - MP1: junction geometry ad/as/pd/ps rewritten in terms of the bound width (area = Lj*W, perimeter = 2*W + c; Lj and c from the netlist)
//   - MN1: junction geometry ad/as/pd/ps rewritten in terms of the bound width (area = Lj*W, perimeter = 2*W + c; Lj and c from the netlist)
//   - MN2: junction geometry ad/as/pd/ps rewritten in terms of the bound width (area = Lj*W, perimeter = 2*W + c; Lj and c from the netlist)
//   - M1: junction geometry ad/as/pd/ps rewritten in terms of the bound width (area = Lj*W, perimeter = 2*W + c; Lj and c from the netlist)
//   - M2: junction geometry ad/as/pd/ps rewritten in terms of the bound width (area = Lj*W, perimeter = 2*W + c; Lj and c from the netlist)
//   - M3: junction geometry ad/as/pd/ps rewritten in terms of the bound width (area = Lj*W, perimeter = 2*W + c; Lj and c from the netlist)
//   - M4: junction geometry ad/as/pd/ps rewritten in terms of the bound width (area = Lj*W, perimeter = 2*W + c; Lj and c from the netlist)
//   - M5: junction geometry ad/as/pd/ps rewritten in terms of the bound width (area = Lj*W, perimeter = 2*W + c; Lj and c from the netlist)
//   - M6: junction geometry ad/as/pd/ps rewritten in terms of the bound width (area = Lj*W, perimeter = 2*W + c; Lj and c from the netlist)
//   - M7: junction geometry ad/as/pd/ps rewritten in terms of the bound width (area = Lj*W, perimeter = 2*W + c; Lj and c from the netlist)
//   - M8: junction geometry ad/as/pd/ps rewritten in terms of the bound width (area = Lj*W, perimeter = 2*W + c; Lj and c from the netlist)
//   - MP4: junction geometry ad/as/pd/ps rewritten in terms of the bound width (area = Lj*W, perimeter = 2*W + c; Lj and c from the netlist)
//   - MP3: junction geometry ad/as/pd/ps rewritten in terms of the bound width (area = Lj*W, perimeter = 2*W + c; Lj and c from the netlist)
//   - MN3: junction geometry ad/as/pd/ps rewritten in terms of the bound width (area = Lj*W, perimeter = 2*W + c; Lj and c from the netlist)
//   - MN4: junction geometry ad/as/pd/ps rewritten in terms of the bound width (area = Lj*W, perimeter = 2*W + c; Lj and c from the netlist)
//   - M9: junction geometry ad/as/pd/ps rewritten in terms of the bound width (area = Lj*W, perimeter = 2*W + c; Lj and c from the netlist)
//   - M10: junction geometry ad/as/pd/ps rewritten in terms of the bound width (area = Lj*W, perimeter = 2*W + c; Lj and c from the netlist)
//   - M11: junction geometry ad/as/pd/ps rewritten in terms of the bound width (area = Lj*W, perimeter = 2*W + c; Lj and c from the netlist)
//   - M12: junction geometry ad/as/pd/ps rewritten in terms of the bound width (area = Lj*W, perimeter = 2*W + c; Lj and c from the netlist)
//   - M13: junction geometry ad/as/pd/ps rewritten in terms of the bound width (area = Lj*W, perimeter = 2*W + c; Lj and c from the netlist)
//   - M14: junction geometry ad/as/pd/ps rewritten in terms of the bound width (area = Lj*W, perimeter = 2*W + c; Lj and c from the netlist)
//   - M15: junction geometry ad/as/pd/ps rewritten in terms of the bound width (area = Lj*W, perimeter = 2*W + c; Lj and c from the netlist)
//   - M16: junction geometry ad/as/pd/ps rewritten in terms of the bound width (area = Lj*W, perimeter = 2*W + c; Lj and c from the netlist)
//   - MP6: junction geometry ad/as/pd/ps rewritten in terms of the bound width (area = Lj*W, perimeter = 2*W + c; Lj and c from the netlist)
//   - MP5: junction geometry ad/as/pd/ps rewritten in terms of the bound width (area = Lj*W, perimeter = 2*W + c; Lj and c from the netlist)
//   - MN5: junction geometry ad/as/pd/ps rewritten in terms of the bound width (area = Lj*W, perimeter = 2*W + c; Lj and c from the netlist)
//   - MN6: junction geometry ad/as/pd/ps rewritten in terms of the bound width (area = Lj*W, perimeter = 2*W + c; Lj and c from the netlist)
//   - M17: junction geometry ad/as/pd/ps rewritten in terms of the bound width (area = Lj*W, perimeter = 2*W + c; Lj and c from the netlist)
//   - M18: junction geometry ad/as/pd/ps rewritten in terms of the bound width (area = Lj*W, perimeter = 2*W + c; Lj and c from the netlist)
//   - M19: junction geometry ad/as/pd/ps rewritten in terms of the bound width (area = Lj*W, perimeter = 2*W + c; Lj and c from the netlist)
//   - M20: junction geometry ad/as/pd/ps rewritten in terms of the bound width (area = Lj*W, perimeter = 2*W + c; Lj and c from the netlist)
//   - M21: junction geometry ad/as/pd/ps rewritten in terms of the bound width (area = Lj*W, perimeter = 2*W + c; Lj and c from the netlist)
//   - M22: junction geometry ad/as/pd/ps rewritten in terms of the bound width (area = Lj*W, perimeter = 2*W + c; Lj and c from the netlist)
//   - M23: junction geometry ad/as/pd/ps rewritten in terms of the bound width (area = Lj*W, perimeter = 2*W + c; Lj and c from the netlist)
//   - M24: junction geometry ad/as/pd/ps rewritten in terms of the bound width (area = Lj*W, perimeter = 2*W + c; Lj and c from the netlist)
//   - widths bound to sizing variables on fold-capable devices are folded symbolically into ceil(W/max) fingers of W/ceil(W/max) (per-device max [1e-05] m): M1, M10, M11, M12, M13, M14, M15, M16, M17, M18, M19, M2, M20, M21, M22, M23, M24, M3, M4, M5, M6, M7, M8, M9, MN1, MN2, MN3, MN4, MN5, MN6, MP1, MP2, MP3, MP4, MP5, MP6
subckt repaired_core (VDD VSS VBP VBN VRO)
parameters N_PI=74.0 W_PI=6.564379300655872e-07 L_PI=4.156082742628978e-06 N_NI=29.0 W_NI=5.63207128117874e-07 L_NI=3.1349370984381273e-07 N_PS=55.0 W_PS=3.3820383226788845e-06 L_PS=3.861470061639868e-06 N_NS=26.0 W_NS=7.753727049941577e-07 L_NS=6.9405055889100745e-06 N_SW1=2.0 W_SW1=1.2048546856972925e-05 L_SW1=5.051669376067145e-07 N_SW2=17.0 W_SW2=1.68853262143759e-06 L_SW2=2.964002408012654e-07 N_LHD=82.0 W_LHD=2.5131068755474398e-05 L_LHD=7.240568194703897e-07 N_HSW=45.0 W_HSW=4.468956667061474e-07 L_HSW=1.2251676722594025e-06 N_SW5=18.0 W_SW5=4.199791247184124e-07 L_SW5=3.4271855601367294e-06 N_SW6=19.0 W_SW6=4.833093877591236e-07 L_SW6=2.633613904061225e-07 N_LSW=4.0 W_LSW=1.616431117045658e-06 L_LSW=8.149822520588248e-07 N_LLD=96.0 W_LLD=2.449635772454497e-06 L_LLD=2.4919711216528e-06 C_LOAD=2.2333992836044953e-14
MP2 (PT1 VBP VDD VDD) pmos1 w=(W_PS/max(1, W_PS/1e-05)) l=L_PS m=N_PS*max(1, W_PS/1e-05) ad=(6.000000000000001e-07*((W_PS/max(1, W_PS/1e-05)))) as=(6.000000000000001e-07*((W_PS/max(1, W_PS/1e-05)))) pd=max(2*((W_PS/max(1, W_PS/1e-05)))+(1.2e-06),0) ps=max(2*((W_PS/max(1, W_PS/1e-05)))+(1.2e-06),0)
MP1 (N1 VRO PT1 VDD) pmos1 w=(W_PI/max(1, W_PI/1e-05)) l=L_PI m=N_PI*max(1, W_PI/1e-05) ad=(6.000000000000001e-07*((W_PI/max(1, W_PI/1e-05)))) as=(6.000000000000001e-07*((W_PI/max(1, W_PI/1e-05)))) pd=max(2*((W_PI/max(1, W_PI/1e-05)))+(1.2e-06),0) ps=max(2*((W_PI/max(1, W_PI/1e-05)))+(1.2e-06),0)
MN1 (N1 VRO NT1 VSS) nmos1 w=(W_NI/max(1, W_NI/1e-05)) l=L_NI m=N_NI*max(1, W_NI/1e-05) ad=(6.000000000000001e-07*((W_NI/max(1, W_NI/1e-05)))) as=(6.000000000000001e-07*((W_NI/max(1, W_NI/1e-05)))) pd=max(2*((W_NI/max(1, W_NI/1e-05)))+(1.2e-06),0) ps=max(2*((W_NI/max(1, W_NI/1e-05)))+(1.2e-06),0)
MN2 (NT1 VBN VSS VSS) nmos1 w=(W_NS/max(1, W_NS/1e-05)) l=L_NS m=N_NS*max(1, W_NS/1e-05) ad=(6.000000000000001e-07*((W_NS/max(1, W_NS/1e-05)))) as=(6.000000000000001e-07*((W_NS/max(1, W_NS/1e-05)))) pd=max(2*((W_NS/max(1, W_NS/1e-05)))+(1.2e-06),0) ps=max(2*((W_NS/max(1, W_NS/1e-05)))+(1.2e-06),0)
M1 (DH1 VSS VRO VDD) pmos1 w=(W_SW1/max(1, W_SW1/1e-05)) l=L_SW1 m=N_SW1*max(1, W_SW1/1e-05) ad=(6.000000000000001e-07*((W_SW1/max(1, W_SW1/1e-05)))) as=(6.000000000000001e-07*((W_SW1/max(1, W_SW1/1e-05)))) pd=max(2*((W_SW1/max(1, W_SW1/1e-05)))+(1.2e-06),0) ps=max(2*((W_SW1/max(1, W_SW1/1e-05)))+(1.2e-06),0)
M2 (VRO VDD DH1 VSS) nmos1 w=(W_SW2/max(1, W_SW2/1e-05)) l=L_SW2 m=N_SW2*max(1, W_SW2/1e-05) ad=(6.000000000000001e-07*((W_SW2/max(1, W_SW2/1e-05)))) as=(6.000000000000001e-07*((W_SW2/max(1, W_SW2/1e-05)))) pd=max(2*((W_SW2/max(1, W_SW2/1e-05)))+(1.2e-06),0) ps=max(2*((W_SW2/max(1, W_SW2/1e-05)))+(1.2e-06),0)
M3 (LH1 LH1 VDD VDD) pmos1 w=(W_LHD/max(1, W_LHD/1e-05)) l=L_LHD m=N_LHD*max(1, W_LHD/1e-05) ad=(6.000000000000001e-07*((W_LHD/max(1, W_LHD/1e-05)))) as=(6.000000000000001e-07*((W_LHD/max(1, W_LHD/1e-05)))) pd=max(2*((W_LHD/max(1, W_LHD/1e-05)))+(1.2e-06),0) ps=max(2*((W_LHD/max(1, W_LHD/1e-05)))+(1.2e-06),0)
M4 (N1 DH1 LH1 VDD) pmos1 w=(W_HSW/max(1, W_HSW/1e-05)) l=L_HSW m=N_HSW*max(1, W_HSW/1e-05) ad=(6.000000000000001e-07*((W_HSW/max(1, W_HSW/1e-05)))) as=(6.000000000000001e-07*((W_HSW/max(1, W_HSW/1e-05)))) pd=max(2*((W_HSW/max(1, W_HSW/1e-05)))+(1.2e-06),0) ps=max(2*((W_HSW/max(1, W_HSW/1e-05)))+(1.2e-06),0)
M5 (DL1 VDD VRO VSS) nmos1 w=(W_SW5/max(1, W_SW5/1e-05)) l=L_SW5 m=N_SW5*max(1, W_SW5/1e-05) ad=(6.000000000000001e-07*((W_SW5/max(1, W_SW5/1e-05)))) as=(6.000000000000001e-07*((W_SW5/max(1, W_SW5/1e-05)))) pd=max(2*((W_SW5/max(1, W_SW5/1e-05)))+(1.2e-06),0) ps=max(2*((W_SW5/max(1, W_SW5/1e-05)))+(1.2e-06),0)
M6 (VRO VSS DL1 VDD) pmos1 w=(W_SW6/max(1, W_SW6/1e-05)) l=L_SW6 m=N_SW6*max(1, W_SW6/1e-05) ad=(6.000000000000001e-07*((W_SW6/max(1, W_SW6/1e-05)))) as=(6.000000000000001e-07*((W_SW6/max(1, W_SW6/1e-05)))) pd=max(2*((W_SW6/max(1, W_SW6/1e-05)))+(1.2e-06),0) ps=max(2*((W_SW6/max(1, W_SW6/1e-05)))+(1.2e-06),0)
M7 (N1 DL1 LL1 VSS) nmos1 w=(W_LSW/max(1, W_LSW/1e-05)) l=L_LSW m=N_LSW*max(1, W_LSW/1e-05) ad=(6.000000000000001e-07*((W_LSW/max(1, W_LSW/1e-05)))) as=(6.000000000000001e-07*((W_LSW/max(1, W_LSW/1e-05)))) pd=max(2*((W_LSW/max(1, W_LSW/1e-05)))+(1.2e-06),0) ps=max(2*((W_LSW/max(1, W_LSW/1e-05)))+(1.2e-06),0)
M8 (LL1 LL1 VSS VSS) nmos1 w=(W_LLD/max(1, W_LLD/1e-05)) l=L_LLD m=N_LLD*max(1, W_LLD/1e-05) ad=(6.000000000000001e-07*((W_LLD/max(1, W_LLD/1e-05)))) as=(6.000000000000001e-07*((W_LLD/max(1, W_LLD/1e-05)))) pd=max(2*((W_LLD/max(1, W_LLD/1e-05)))+(1.2e-06),0) ps=max(2*((W_LLD/max(1, W_LLD/1e-05)))+(1.2e-06),0)
C1 (N1 VSS) capacitor c=C_LOAD
MP4 (PT2 VBP VDD VDD) pmos1 w=(W_PS/max(1, W_PS/1e-05)) l=L_PS m=N_PS*max(1, W_PS/1e-05) ad=(6.000000000000001e-07*((W_PS/max(1, W_PS/1e-05)))) as=(6.000000000000001e-07*((W_PS/max(1, W_PS/1e-05)))) pd=max(2*((W_PS/max(1, W_PS/1e-05)))+(1.2e-06),0) ps=max(2*((W_PS/max(1, W_PS/1e-05)))+(1.2e-06),0)
MP3 (N2 N1 PT2 VDD) pmos1 w=(W_PI/max(1, W_PI/1e-05)) l=L_PI m=N_PI*max(1, W_PI/1e-05) ad=(6.000000000000001e-07*((W_PI/max(1, W_PI/1e-05)))) as=(6.000000000000001e-07*((W_PI/max(1, W_PI/1e-05)))) pd=max(2*((W_PI/max(1, W_PI/1e-05)))+(1.2e-06),0) ps=max(2*((W_PI/max(1, W_PI/1e-05)))+(1.2e-06),0)
MN3 (N2 N1 NT2 VSS) nmos1 w=(W_NI/max(1, W_NI/1e-05)) l=L_NI m=N_NI*max(1, W_NI/1e-05) ad=(6.000000000000001e-07*((W_NI/max(1, W_NI/1e-05)))) as=(6.000000000000001e-07*((W_NI/max(1, W_NI/1e-05)))) pd=max(2*((W_NI/max(1, W_NI/1e-05)))+(1.2e-06),0) ps=max(2*((W_NI/max(1, W_NI/1e-05)))+(1.2e-06),0)
MN4 (NT2 VBN VSS VSS) nmos1 w=(W_NS/max(1, W_NS/1e-05)) l=L_NS m=N_NS*max(1, W_NS/1e-05) ad=(6.000000000000001e-07*((W_NS/max(1, W_NS/1e-05)))) as=(6.000000000000001e-07*((W_NS/max(1, W_NS/1e-05)))) pd=max(2*((W_NS/max(1, W_NS/1e-05)))+(1.2e-06),0) ps=max(2*((W_NS/max(1, W_NS/1e-05)))+(1.2e-06),0)
M9 (DH2 VSS N1 VDD) pmos1 w=(W_SW1/max(1, W_SW1/1e-05)) l=L_SW1 m=N_SW1*max(1, W_SW1/1e-05) ad=(6.000000000000001e-07*((W_SW1/max(1, W_SW1/1e-05)))) as=(6.000000000000001e-07*((W_SW1/max(1, W_SW1/1e-05)))) pd=max(2*((W_SW1/max(1, W_SW1/1e-05)))+(1.2e-06),0) ps=max(2*((W_SW1/max(1, W_SW1/1e-05)))+(1.2e-06),0)
M10 (N1 VDD DH2 VSS) nmos1 w=(W_SW2/max(1, W_SW2/1e-05)) l=L_SW2 m=N_SW2*max(1, W_SW2/1e-05) ad=(6.000000000000001e-07*((W_SW2/max(1, W_SW2/1e-05)))) as=(6.000000000000001e-07*((W_SW2/max(1, W_SW2/1e-05)))) pd=max(2*((W_SW2/max(1, W_SW2/1e-05)))+(1.2e-06),0) ps=max(2*((W_SW2/max(1, W_SW2/1e-05)))+(1.2e-06),0)
M11 (LH2 LH2 VDD VDD) pmos1 w=(W_LHD/max(1, W_LHD/1e-05)) l=L_LHD m=N_LHD*max(1, W_LHD/1e-05) ad=(6.000000000000001e-07*((W_LHD/max(1, W_LHD/1e-05)))) as=(6.000000000000001e-07*((W_LHD/max(1, W_LHD/1e-05)))) pd=max(2*((W_LHD/max(1, W_LHD/1e-05)))+(1.2e-06),0) ps=max(2*((W_LHD/max(1, W_LHD/1e-05)))+(1.2e-06),0)
M12 (N2 DH2 LH2 VDD) pmos1 w=(W_HSW/max(1, W_HSW/1e-05)) l=L_HSW m=N_HSW*max(1, W_HSW/1e-05) ad=(6.000000000000001e-07*((W_HSW/max(1, W_HSW/1e-05)))) as=(6.000000000000001e-07*((W_HSW/max(1, W_HSW/1e-05)))) pd=max(2*((W_HSW/max(1, W_HSW/1e-05)))+(1.2e-06),0) ps=max(2*((W_HSW/max(1, W_HSW/1e-05)))+(1.2e-06),0)
M13 (DL2 VDD N1 VSS) nmos1 w=(W_SW5/max(1, W_SW5/1e-05)) l=L_SW5 m=N_SW5*max(1, W_SW5/1e-05) ad=(6.000000000000001e-07*((W_SW5/max(1, W_SW5/1e-05)))) as=(6.000000000000001e-07*((W_SW5/max(1, W_SW5/1e-05)))) pd=max(2*((W_SW5/max(1, W_SW5/1e-05)))+(1.2e-06),0) ps=max(2*((W_SW5/max(1, W_SW5/1e-05)))+(1.2e-06),0)
M14 (N1 VSS DL2 VDD) pmos1 w=(W_SW6/max(1, W_SW6/1e-05)) l=L_SW6 m=N_SW6*max(1, W_SW6/1e-05) ad=(6.000000000000001e-07*((W_SW6/max(1, W_SW6/1e-05)))) as=(6.000000000000001e-07*((W_SW6/max(1, W_SW6/1e-05)))) pd=max(2*((W_SW6/max(1, W_SW6/1e-05)))+(1.2e-06),0) ps=max(2*((W_SW6/max(1, W_SW6/1e-05)))+(1.2e-06),0)
M15 (N2 DL2 LL2 VSS) nmos1 w=(W_LSW/max(1, W_LSW/1e-05)) l=L_LSW m=N_LSW*max(1, W_LSW/1e-05) ad=(6.000000000000001e-07*((W_LSW/max(1, W_LSW/1e-05)))) as=(6.000000000000001e-07*((W_LSW/max(1, W_LSW/1e-05)))) pd=max(2*((W_LSW/max(1, W_LSW/1e-05)))+(1.2e-06),0) ps=max(2*((W_LSW/max(1, W_LSW/1e-05)))+(1.2e-06),0)
M16 (LL2 LL2 VSS VSS) nmos1 w=(W_LLD/max(1, W_LLD/1e-05)) l=L_LLD m=N_LLD*max(1, W_LLD/1e-05) ad=(6.000000000000001e-07*((W_LLD/max(1, W_LLD/1e-05)))) as=(6.000000000000001e-07*((W_LLD/max(1, W_LLD/1e-05)))) pd=max(2*((W_LLD/max(1, W_LLD/1e-05)))+(1.2e-06),0) ps=max(2*((W_LLD/max(1, W_LLD/1e-05)))+(1.2e-06),0)
C2 (N2 VSS) capacitor c=C_LOAD
MP6 (PT3 VBP VDD VDD) pmos1 w=(W_PS/max(1, W_PS/1e-05)) l=L_PS m=N_PS*max(1, W_PS/1e-05) ad=(6.000000000000001e-07*((W_PS/max(1, W_PS/1e-05)))) as=(6.000000000000001e-07*((W_PS/max(1, W_PS/1e-05)))) pd=max(2*((W_PS/max(1, W_PS/1e-05)))+(1.2e-06),0) ps=max(2*((W_PS/max(1, W_PS/1e-05)))+(1.2e-06),0)
MP5 (VRO N2 PT3 VDD) pmos1 w=(W_PI/max(1, W_PI/1e-05)) l=L_PI m=N_PI*max(1, W_PI/1e-05) ad=(6.000000000000001e-07*((W_PI/max(1, W_PI/1e-05)))) as=(6.000000000000001e-07*((W_PI/max(1, W_PI/1e-05)))) pd=max(2*((W_PI/max(1, W_PI/1e-05)))+(1.2e-06),0) ps=max(2*((W_PI/max(1, W_PI/1e-05)))+(1.2e-06),0)
MN5 (VRO N2 NT3 VSS) nmos1 w=(W_NI/max(1, W_NI/1e-05)) l=L_NI m=N_NI*max(1, W_NI/1e-05) ad=(6.000000000000001e-07*((W_NI/max(1, W_NI/1e-05)))) as=(6.000000000000001e-07*((W_NI/max(1, W_NI/1e-05)))) pd=max(2*((W_NI/max(1, W_NI/1e-05)))+(1.2e-06),0) ps=max(2*((W_NI/max(1, W_NI/1e-05)))+(1.2e-06),0)
MN6 (NT3 VBN VSS VSS) nmos1 w=(W_NS/max(1, W_NS/1e-05)) l=L_NS m=N_NS*max(1, W_NS/1e-05) ad=(6.000000000000001e-07*((W_NS/max(1, W_NS/1e-05)))) as=(6.000000000000001e-07*((W_NS/max(1, W_NS/1e-05)))) pd=max(2*((W_NS/max(1, W_NS/1e-05)))+(1.2e-06),0) ps=max(2*((W_NS/max(1, W_NS/1e-05)))+(1.2e-06),0)
M17 (DH3 VSS N2 VDD) pmos1 w=(W_SW1/max(1, W_SW1/1e-05)) l=L_SW1 m=N_SW1*max(1, W_SW1/1e-05) ad=(6.000000000000001e-07*((W_SW1/max(1, W_SW1/1e-05)))) as=(6.000000000000001e-07*((W_SW1/max(1, W_SW1/1e-05)))) pd=max(2*((W_SW1/max(1, W_SW1/1e-05)))+(1.2e-06),0) ps=max(2*((W_SW1/max(1, W_SW1/1e-05)))+(1.2e-06),0)
M18 (N2 VDD DH3 VSS) nmos1 w=(W_SW2/max(1, W_SW2/1e-05)) l=L_SW2 m=N_SW2*max(1, W_SW2/1e-05) ad=(6.000000000000001e-07*((W_SW2/max(1, W_SW2/1e-05)))) as=(6.000000000000001e-07*((W_SW2/max(1, W_SW2/1e-05)))) pd=max(2*((W_SW2/max(1, W_SW2/1e-05)))+(1.2e-06),0) ps=max(2*((W_SW2/max(1, W_SW2/1e-05)))+(1.2e-06),0)
M19 (LH3 LH3 VDD VDD) pmos1 w=(W_LHD/max(1, W_LHD/1e-05)) l=L_LHD m=N_LHD*max(1, W_LHD/1e-05) ad=(6.000000000000001e-07*((W_LHD/max(1, W_LHD/1e-05)))) as=(6.000000000000001e-07*((W_LHD/max(1, W_LHD/1e-05)))) pd=max(2*((W_LHD/max(1, W_LHD/1e-05)))+(1.2e-06),0) ps=max(2*((W_LHD/max(1, W_LHD/1e-05)))+(1.2e-06),0)
M20 (VRO DH3 LH3 VDD) pmos1 w=(W_HSW/max(1, W_HSW/1e-05)) l=L_HSW m=N_HSW*max(1, W_HSW/1e-05) ad=(6.000000000000001e-07*((W_HSW/max(1, W_HSW/1e-05)))) as=(6.000000000000001e-07*((W_HSW/max(1, W_HSW/1e-05)))) pd=max(2*((W_HSW/max(1, W_HSW/1e-05)))+(1.2e-06),0) ps=max(2*((W_HSW/max(1, W_HSW/1e-05)))+(1.2e-06),0)
M21 (DL3 VDD N2 VSS) nmos1 w=(W_SW5/max(1, W_SW5/1e-05)) l=L_SW5 m=N_SW5*max(1, W_SW5/1e-05) ad=(6.000000000000001e-07*((W_SW5/max(1, W_SW5/1e-05)))) as=(6.000000000000001e-07*((W_SW5/max(1, W_SW5/1e-05)))) pd=max(2*((W_SW5/max(1, W_SW5/1e-05)))+(1.2e-06),0) ps=max(2*((W_SW5/max(1, W_SW5/1e-05)))+(1.2e-06),0)
M22 (N2 VSS DL3 VDD) pmos1 w=(W_SW6/max(1, W_SW6/1e-05)) l=L_SW6 m=N_SW6*max(1, W_SW6/1e-05) ad=(6.000000000000001e-07*((W_SW6/max(1, W_SW6/1e-05)))) as=(6.000000000000001e-07*((W_SW6/max(1, W_SW6/1e-05)))) pd=max(2*((W_SW6/max(1, W_SW6/1e-05)))+(1.2e-06),0) ps=max(2*((W_SW6/max(1, W_SW6/1e-05)))+(1.2e-06),0)
M23 (VRO DL3 LL3 VSS) nmos1 w=(W_LSW/max(1, W_LSW/1e-05)) l=L_LSW m=N_LSW*max(1, W_LSW/1e-05) ad=(6.000000000000001e-07*((W_LSW/max(1, W_LSW/1e-05)))) as=(6.000000000000001e-07*((W_LSW/max(1, W_LSW/1e-05)))) pd=max(2*((W_LSW/max(1, W_LSW/1e-05)))+(1.2e-06),0) ps=max(2*((W_LSW/max(1, W_LSW/1e-05)))+(1.2e-06),0)
M24 (LL3 LL3 VSS VSS) nmos1 w=(W_LLD/max(1, W_LLD/1e-05)) l=L_LLD m=N_LLD*max(1, W_LLD/1e-05) ad=(6.000000000000001e-07*((W_LLD/max(1, W_LLD/1e-05)))) as=(6.000000000000001e-07*((W_LLD/max(1, W_LLD/1e-05)))) pd=max(2*((W_LLD/max(1, W_LLD/1e-05)))+(1.2e-06),0) ps=max(2*((W_LLD/max(1, W_LLD/1e-05)))+(1.2e-06),0)
C3 (VRO VSS) capacitor c=C_LOAD
ends repaired_core
