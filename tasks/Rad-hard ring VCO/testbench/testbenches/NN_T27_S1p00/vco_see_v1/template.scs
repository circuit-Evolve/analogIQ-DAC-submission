// analogiq 0.1.0 testbench - generated, do not edit
// task rvco24_um_task_001  topology rvco24_um
// recipe vco_see_v1 v1  condition NN_T27_S1p00 (models NN, 27 C, supply 1.8 V)
// request rvco24_um_task_001__plan  candidate 6be86fc6bd9efaf9
// execution profile search_full
simulator lang=spectre
global 0
include "<CADENCE_SHARED>/FOUNDRY/analog/180nm/models/spectre/gpdk.scs" section=NN
include "dut.scs"

parameters cl=1e-14 vsup=1.8
// Sizing variables set in the testbench (external-bias values).
parameters V_BN={{V_BN}} V_BP={{V_BP}}
// Supplies (charged to the DUT power metrics).
VSUP (vdd 0) vsource dc=vsup
// External bias (topology external_bias; reported separately as bias power).
VB_VSS (b_VSS 0) vsource dc=0.0
VB_VBP (b_VBP 0) vsource dc=V_BP
VB_VBN (b_VBN 0) vsource dc=V_BN

CL1 (outp 0) capacitor c=cl
// Start-up kick: current pulse into outp (start-up assistance, see recipe doc).
IKICK (0 outp) isource type=pulse val0=0 val1=0.0001 delay=0 rise=5.0000000000000005e-12 fall=5.0000000000000005e-12 width=5e-11

XDUT (vdd b_VSS b_VBP b_VBN outp) repaired_core C_LOAD={{C_LOAD}} L_HSW={{L_HSW}} L_LHD={{L_LHD}} L_LLD={{L_LLD}} L_LSW={{L_LSW}} L_NI={{L_NI}} L_NS={{L_NS}} L_PI={{L_PI}} L_PS={{L_PS}} L_SW1={{L_SW1}} L_SW2={{L_SW2}} L_SW5={{L_SW5}} L_SW6={{L_SW6}} N_HSW={{N_HSW}} N_LHD={{N_LHD}} N_LLD={{N_LLD}} N_LSW={{N_LSW}} N_NI={{N_NI}} N_NS={{N_NS}} N_PI={{N_PI}} N_PS={{N_PS}} N_SW1={{N_SW1}} N_SW2={{N_SW2}} N_SW5={{N_SW5}} N_SW6={{N_SW6}} W_HSW={{W_HSW}} W_LHD={{W_LHD}} W_LLD={{W_LLD}} W_LSW={{W_LSW}} W_NI={{W_NI}} W_NS={{W_NS}} W_PI={{W_PI}} W_PS={{W_PS}} W_SW1={{W_SW1}} W_SW2={{W_SW2}} W_SW5={{W_SW5}} W_SW6={{W_SW6}}

opts options temp=27.0 tnom=27 reltol=0.0001 save=selected
save VB_VBN:p VB_VBP:p VB_VSS:p VSUP:p outp vdd

ISEE0 (0 XDUT.N1) isource type=pwl wave=[0.0 0.0 4.6e-06 0.0 4.6001e-06 0.00011890367806258925 4.6002e-06 0.00011310467725449495 4.600378698224852e-06 0.00010343719582229614 4.600852071005917e-06 8.163664437123026e-05 4.601514792899409e-06 5.8610700810396446e-05 4.602366863905326e-06 3.827824750725529e-05 4.6034082840236685e-06 2.2741051456998745e-05 4.604639053254438e-06 1.2290014582160297e-05 4.6060591715976335e-06 6.041956833213609e-06 4.607668639053254e-06 2.702005326017628e-06 4.609467455621302e-06 1.0992036099606076e-06 4.6114556213017755e-06 4.0677425087224927e-07 4.613633136094675e-06 1.369342616843481e-07 4.616e-06 4.1932828487813984e-08 4.616100000000001e-06 0.0 6.6e-06 0.0 6.6001000000000006e-06 0.00011890367806258925 6.6002e-06 0.00011310467725449495 6.6003786982248525e-06 0.00010343719582229614 6.6008520710059175e-06 8.163664437123026e-05 6.601514792899409e-06 5.8610700810396446e-05 6.602366863905326e-06 3.827824750725529e-05 6.603408284023669e-06 2.2741051456998745e-05 6.604639053254438e-06 1.2290014582160297e-05 6.606059171597634e-06 6.041956833213609e-06 6.607668639053254e-06 2.702005326017628e-06 6.609467455621302e-06 1.0992036099606076e-06 6.611455621301776e-06 4.0677425087224927e-07 6.613633136094675e-06 1.369342616843481e-07 6.616000000000001e-06 4.1932828487813984e-08 6.616100000000001e-06 0.0 8.599999999999999e-06 0.0 8.6001e-06 0.00011890367806258925 8.6002e-06 0.00011310467725449495 8.60037869822485e-06 0.00010343719582229614 8.600852071005916e-06 8.163664437123026e-05 8.601514792899408e-06 5.8610700810396446e-05 8.602366863905325e-06 3.827824750725529e-05 8.603408284023667e-06 2.2741051456998745e-05 8.604639053254438e-06 1.2290014582160297e-05 8.606059171597632e-06 6.041956833213609e-06 8.607668639053253e-06 2.702005326017628e-06 8.6094674556213e-06 1.0992036099606076e-06 8.611455621301774e-06 4.0677425087224927e-07 8.613633136094673e-06 1.369342616843481e-07 8.615999999999998e-06 4.1932828487813984e-08 8.616099999999999e-06 0.0 1.0599999999999998e-05 0.0 1.0600099999999999e-05 0.00011890367806258925 1.0600199999999999e-05 0.00011310467725449495 1.060037869822485e-05 0.00010343719582229614 1.0600852071005916e-05 8.163664437123026e-05 1.0601514792899407e-05 5.8610700810396446e-05 1.0602366863905324e-05 3.827824750725529e-05 1.0603408284023667e-05 2.2741051456998745e-05 1.0604639053254437e-05 1.2290014582160297e-05 1.0606059171597631e-05 6.041956833213609e-06 1.0607668639053252e-05 2.702005326017628e-06 1.06094674556213e-05 1.0992036099606076e-06 1.0611455621301774e-05 4.0677425087224927e-07 1.0613633136094672e-05 1.369342616843481e-07 1.0615999999999998e-05 4.1932828487813984e-08 1.0616099999999998e-05 0.0 5.260000000000002e-05 0.0 5.260010000000002e-05 0.0006182991259254641 5.260020000000002e-05 0.0005881443217233737 5.260037869822487e-05 0.0005378734182759399 5.2600852071005934e-05 0.00042451055073039733 5.260151479289942e-05 0.0003047756442140615 5.2602366863905346e-05 0.00019904688703772754 5.260340828402369e-05 0.00011825346757639348 5.260463905325445e-05 6.390807582723354e-05 5.260605917159765e-05 3.1418175532710766e-05 5.260766863905327e-05 1.4050427695291666e-05 5.260946745562132e-05 5.715858771795159e-06 5.261145562130179e-05 2.1152261045356957e-06 5.261363313609469e-05 7.1205816075861e-07 5.261600000000002e-05 2.1805070813663269e-07 5.261610000000002e-05 0.0 5.460000000000002e-05 0.0 5.460010000000002e-05 0.0006182991259254641 5.460020000000002e-05 0.0005881443217233737 5.460037869822487e-05 0.0005378734182759399 5.4600852071005935e-05 0.00042451055073039733 5.4601514792899425e-05 0.0003047756442140615 5.460236686390535e-05 0.00019904688703772754 5.460340828402369e-05 0.00011825346757639348 5.4604639053254455e-05 6.390807582723354e-05 5.4606059171597654e-05 3.1418175532710766e-05 5.460766863905327e-05 1.4050427695291666e-05 5.460946745562132e-05 5.715858771795159e-06 5.461145562130179e-05 2.1152261045356957e-06 5.461363313609469e-05 7.1205816075861e-07 5.461600000000002e-05 2.1805070813663269e-07 5.461610000000002e-05 0.0 5.660000000000002e-05 0.0 5.660010000000002e-05 0.0006182991259254641 5.660020000000002e-05 0.0005881443217233737 5.660037869822487e-05 0.0005378734182759399 5.6600852071005936e-05 0.00042451055073039733 5.6601514792899426e-05 0.0003047756442140615 5.660236686390535e-05 0.00019904688703772754 5.660340828402369e-05 0.00011825346757639348 5.6604639053254456e-05 6.390807582723354e-05 5.6606059171597655e-05 3.1418175532710766e-05 5.660766863905327e-05 1.4050427695291666e-05 5.660946745562132e-05 5.715858771795159e-06 5.661145562130179e-05 2.1152261045356957e-06 5.6613633136094694e-05 7.1205816075861e-07 5.661600000000002e-05 2.1805070813663269e-07 5.661610000000002e-05 0.0 5.860000000000002e-05 0.0 5.860010000000002e-05 0.0006182991259254641 5.860020000000002e-05 0.0005881443217233737 5.860037869822487e-05 0.0005378734182759399 5.860085207100594e-05 0.00042451055073039733 5.860151479289943e-05 0.0003047756442140615 5.860236686390535e-05 0.00019904688703772754 5.860340828402369e-05 0.00011825346757639348 5.860463905325446e-05 6.390807582723354e-05 5.8606059171597656e-05 3.1418175532710766e-05 5.8607668639053274e-05 1.4050427695291666e-05 5.8609467455621324e-05 5.715858771795159e-06 5.8611455621301794e-05 2.1152261045356957e-06 5.8613633136094696e-05 7.1205816075861e-07 5.861600000000002e-05 2.1805070813663269e-07 5.861610000000002e-05 0.0]
ISEE1 (0 XDUT.N1) isource type=pwl wave=[0.0 0.0 1.2599999999999998e-05 -0.0 1.2600099999999998e-05 -0.00011890367806258925 1.2600199999999998e-05 -0.00011310467725449495 1.260037869822485e-05 -0.00010343719582229614 1.2600852071005915e-05 -8.163664437123026e-05 1.2601514792899407e-05 -5.8610700810396446e-05 1.2602366863905324e-05 -3.827824750725529e-05 1.2603408284023666e-05 -2.2741051456998745e-05 1.2604639053254437e-05 -1.2290014582160297e-05 1.260605917159763e-05 -6.041956833213609e-06 1.2607668639053252e-05 -2.702005326017628e-06 1.2609467455621299e-05 -1.0992036099606076e-06 1.2611455621301773e-05 -4.0677425087224927e-07 1.2613633136094672e-05 -1.369342616843481e-07 1.2615999999999997e-05 -4.1932828487813984e-08 1.2616099999999998e-05 -0.0 1.4599999999999997e-05 -0.0 1.4600099999999998e-05 -0.00011890367806258925 1.4600199999999998e-05 -0.00011310467725449495 1.4600378698224849e-05 -0.00010343719582229614 1.4600852071005915e-05 -8.163664437123026e-05 1.4601514792899406e-05 -5.8610700810396446e-05 1.4602366863905323e-05 -3.827824750725529e-05 1.4603408284023666e-05 -2.2741051456998745e-05 1.4604639053254436e-05 -1.2290014582160297e-05 1.460605917159763e-05 -6.041956833213609e-06 1.4607668639053251e-05 -2.702005326017628e-06 1.4609467455621299e-05 -1.0992036099606076e-06 1.4611455621301773e-05 -4.0677425087224927e-07 1.4613633136094671e-05 -1.369342616843481e-07 1.4615999999999997e-05 -4.1932828487813984e-08 1.4616099999999997e-05 -0.0 1.66e-05 -0.0 1.66001e-05 -0.00011890367806258925 1.66002e-05 -0.00011310467725449495 1.660037869822485e-05 -0.00010343719582229614 1.660085207100592e-05 -8.163664437123026e-05 1.660151479289941e-05 -5.8610700810396446e-05 1.6602366863905324e-05 -3.827824750725529e-05 1.660340828402367e-05 -2.2741051456998745e-05 1.660463905325444e-05 -1.2290014582160297e-05 1.6606059171597635e-05 -6.041956833213609e-06 1.6607668639053256e-05 -2.702005326017628e-06 1.6609467455621303e-05 -1.0992036099606076e-06 1.6611455621301776e-05 -4.0677425087224927e-07 1.6613633136094674e-05 -1.369342616843481e-07 1.6616e-05 -4.1932828487813984e-08 1.6616100000000002e-05 -0.0 1.86e-05 -0.0 1.8600100000000002e-05 -0.00011890367806258925 1.8600200000000002e-05 -0.00011310467725449495 1.8600378698224853e-05 -0.00010343719582229614 1.860085207100592e-05 -8.163664437123026e-05 1.860151479289941e-05 -5.8610700810396446e-05 1.8602366863905325e-05 -3.827824750725529e-05 1.860340828402367e-05 -2.2741051456998745e-05 1.860463905325444e-05 -1.2290014582160297e-05 1.8606059171597636e-05 -6.041956833213609e-06 1.8607668639053257e-05 -2.702005326017628e-06 1.8609467455621304e-05 -1.0992036099606076e-06 1.8611455621301777e-05 -4.0677425087224927e-07 1.8613633136094675e-05 -1.369342616843481e-07 1.8616000000000003e-05 -4.1932828487813984e-08 1.8616100000000003e-05 -0.0 6.060000000000002e-05 -0.0 6.060010000000002e-05 -0.0006182991259254641 6.060020000000002e-05 -0.0005881443217233737 6.0600378698224874e-05 -0.0005378734182759399 6.060085207100594e-05 -0.00042451055073039733 6.060151479289943e-05 -0.0003047756442140615 6.060236686390535e-05 -0.00019904688703772754 6.060340828402369e-05 -0.00011825346757639348 6.060463905325446e-05 -6.390807582723354e-05 6.060605917159766e-05 -3.1418175532710766e-05 6.0607668639053275e-05 -1.4050427695291666e-05 6.0609467455621326e-05 -5.715858771795159e-06 6.0611455621301795e-05 -2.1152261045356957e-06 6.06136331360947e-05 -7.1205816075861e-07 6.0616000000000024e-05 -2.1805070813663269e-07 6.0616100000000024e-05 -0.0 6.260000000000002e-05 -0.0 6.260010000000001e-05 -0.0006182991259254641 6.260020000000002e-05 -0.0005881443217233737 6.260037869822487e-05 -0.0005378734182759399 6.260085207100593e-05 -0.00042451055073039733 6.260151479289942e-05 -0.0003047756442140615 6.260236686390534e-05 -0.00019904688703772754 6.260340828402369e-05 -0.00011825346757639348 6.260463905325446e-05 -6.390807582723354e-05 6.260605917159765e-05 -3.1418175532710766e-05 6.260766863905327e-05 -1.4050427695291666e-05 6.260946745562131e-05 -5.715858771795159e-06 6.26114556213018e-05 -2.1152261045356957e-06 6.261363313609469e-05 -7.1205816075861e-07 6.261600000000001e-05 -2.1805070813663269e-07 6.26161e-05 -0.0 6.460000000000001e-05 -0.0 6.46001e-05 -0.0006182991259254641 6.460020000000001e-05 -0.0005881443217233737 6.460037869822486e-05 -0.0005378734182759399 6.460085207100593e-05 -0.00042451055073039733 6.460151479289942e-05 -0.0003047756442140615 6.460236686390533e-05 -0.00019904688703772754 6.460340828402369e-05 -0.00011825346757639348 6.460463905325445e-05 -6.390807582723354e-05 6.460605917159765e-05 -3.1418175532710766e-05 6.460766863905326e-05 -1.4050427695291666e-05 6.460946745562131e-05 -5.715858771795159e-06 6.461145562130179e-05 -2.1152261045356957e-06 6.461363313609469e-05 -7.1205816075861e-07 6.4616e-05 -2.1805070813663269e-07 6.46161e-05 -0.0 6.66e-05 -0.0 6.66001e-05 -0.0006182991259254641 6.66002e-05 -0.0005881443217233737 6.660037869822486e-05 -0.0005378734182759399 6.660085207100592e-05 -0.00042451055073039733 6.660151479289941e-05 -0.0003047756442140615 6.660236686390533e-05 -0.00019904688703772754 6.660340828402368e-05 -0.00011825346757639348 6.660463905325445e-05 -6.390807582723354e-05 6.660605917159764e-05 -3.1418175532710766e-05 6.660766863905326e-05 -1.4050427695291666e-05 6.66094674556213e-05 -5.715858771795159e-06 6.661145562130178e-05 -2.1152261045356957e-06 6.661363313609468e-05 -7.1205816075861e-07 6.6616e-05 -2.1805070813663269e-07 6.66161e-05 -0.0]
ISEE2 (0 XDUT.N2) isource type=pwl wave=[0.0 0.0 2.0600000000000003e-05 0.0 2.0600100000000003e-05 0.00011890367806258925 2.0600200000000003e-05 0.00011310467725449495 2.0600378698224854e-05 0.00010343719582229614 2.060085207100592e-05 8.163664437123026e-05 2.060151479289941e-05 5.8610700810396446e-05 2.0602366863905327e-05 3.827824750725529e-05 2.060340828402367e-05 2.2741051456998745e-05 2.060463905325444e-05 1.2290014582160297e-05 2.0606059171597637e-05 6.041956833213609e-06 2.060766863905326e-05 2.702005326017628e-06 2.0609467455621305e-05 1.0992036099606076e-06 2.0611455621301778e-05 4.0677425087224927e-07 2.0613633136094676e-05 1.369342616843481e-07 2.0616000000000004e-05 4.1932828487813984e-08 2.0616100000000004e-05 0.0 2.2600000000000004e-05 0.0 2.2600100000000004e-05 0.00011890367806258925 2.2600200000000004e-05 0.00011310467725449495 2.2600378698224855e-05 0.00010343719582229614 2.2600852071005923e-05 8.163664437123026e-05 2.2601514792899412e-05 5.8610700810396446e-05 2.2602366863905328e-05 3.827824750725529e-05 2.2603408284023672e-05 2.2741051456998745e-05 2.2604639053254442e-05 1.2290014582160297e-05 2.2606059171597638e-05 6.041956833213609e-06 2.260766863905326e-05 2.702005326017628e-06 2.2609467455621307e-05 1.0992036099606076e-06 2.261145562130178e-05 4.0677425087224927e-07 2.2613633136094678e-05 1.369342616843481e-07 2.2616000000000005e-05 4.1932828487813984e-08 2.2616100000000005e-05 0.0 2.4600000000000005e-05 0.0 2.4600100000000005e-05 0.00011890367806258925 2.4600200000000005e-05 0.00011310467725449495 2.4600378698224856e-05 0.00010343719582229614 2.4600852071005924e-05 8.163664437123026e-05 2.4601514792899414e-05 5.8610700810396446e-05 2.460236686390533e-05 3.827824750725529e-05 2.4603408284023673e-05 2.2741051456998745e-05 2.4604639053254444e-05 1.2290014582160297e-05 2.460605917159764e-05 6.041956833213609e-06 2.460766863905326e-05 2.702005326017628e-06 2.4609467455621308e-05 1.0992036099606076e-06 2.461145562130178e-05 4.0677425087224927e-07 2.461363313609468e-05 1.369342616843481e-07 2.4616000000000006e-05 4.1932828487813984e-08 2.4616100000000006e-05 0.0 2.6600000000000006e-05 0.0 2.6600100000000006e-05 0.00011890367806258925 2.6600200000000007e-05 0.00011310467725449495 2.6600378698224858e-05 0.00010343719582229614 2.6600852071005925e-05 8.163664437123026e-05 2.6601514792899415e-05 5.8610700810396446e-05 2.660236686390533e-05 3.827824750725529e-05 2.6603408284023675e-05 2.2741051456998745e-05 2.6604639053254445e-05 1.2290014582160297e-05 2.660605917159764e-05 6.041956833213609e-06 2.6607668639053262e-05 2.702005326017628e-06 2.660946745562131e-05 1.0992036099606076e-06 2.661145562130178e-05 4.0677425087224927e-07 2.661363313609468e-05 1.369342616843481e-07 2.6616000000000007e-05 4.1932828487813984e-08 2.6616100000000008e-05 0.0 6.86e-05 0.0 6.86001e-05 0.0006182991259254641 6.86002e-05 0.0005881443217233737 6.860037869822485e-05 0.0005378734182759399 6.860085207100592e-05 0.00042451055073039733 6.86015147928994e-05 0.0003047756442140615 6.860236686390532e-05 0.00019904688703772754 6.860340828402368e-05 0.00011825346757639348 6.860463905325444e-05 6.390807582723354e-05 6.860605917159763e-05 3.1418175532710766e-05 6.860766863905325e-05 1.4050427695291666e-05 6.86094674556213e-05 5.715858771795159e-06 6.861145562130178e-05 2.1152261045356957e-06 6.861363313609467e-05 7.1205816075861e-07 6.8616e-05 2.1805070813663269e-07 6.861609999999999e-05 0.0 7.06e-05 0.0 7.060009999999999e-05 0.0006182991259254641 7.06002e-05 0.0005881443217233737 7.060037869822485e-05 0.0005378734182759399 7.060085207100591e-05 0.00042451055073039733 7.06015147928994e-05 0.0003047756442140615 7.060236686390532e-05 0.00019904688703772754 7.060340828402367e-05 0.00011825346757639348 7.060463905325444e-05 6.390807582723354e-05 7.060605917159763e-05 3.1418175532710766e-05 7.060766863905325e-05 1.4050427695291666e-05 7.060946745562129e-05 5.715858771795159e-06 7.061145562130177e-05 2.1152261045356957e-06 7.061363313609467e-05 7.1205816075861e-07 7.061599999999999e-05 2.1805070813663269e-07 7.061609999999998e-05 0.0 7.259999999999999e-05 0.0 7.260009999999998e-05 0.0006182991259254641 7.260019999999999e-05 0.0005881443217233737 7.260037869822484e-05 0.0005378734182759399 7.26008520710059e-05 0.00042451055073039733 7.26015147928994e-05 0.0003047756442140615 7.260236686390531e-05 0.00019904688703772754 7.260340828402366e-05 0.00011825346757639348 7.260463905325443e-05 6.390807582723354e-05 7.260605917159762e-05 3.1418175532710766e-05 7.260766863905324e-05 1.4050427695291666e-05 7.260946745562129e-05 5.715858771795159e-06 7.261145562130177e-05 2.1152261045356957e-06 7.261363313609466e-05 7.1205816075861e-07 7.261599999999998e-05 2.1805070813663269e-07 7.261609999999998e-05 0.0 7.459999999999998e-05 0.0 7.460009999999998e-05 0.0006182991259254641 7.460019999999998e-05 0.0005881443217233737 7.460037869822484e-05 0.0005378734182759399 7.46008520710059e-05 0.00042451055073039733 7.460151479289939e-05 0.0003047756442140615 7.46023668639053e-05 0.00019904688703772754 7.460340828402366e-05 0.00011825346757639348 7.460463905325443e-05 6.390807582723354e-05 7.460605917159762e-05 3.1418175532710766e-05 7.460766863905324e-05 1.4050427695291666e-05 7.460946745562128e-05 5.715858771795159e-06 7.461145562130176e-05 2.1152261045356957e-06 7.461363313609466e-05 7.1205816075861e-07 7.461599999999998e-05 2.1805070813663269e-07 7.461609999999997e-05 0.0]
ISEE3 (0 XDUT.N2) isource type=pwl wave=[0.0 0.0 2.8600000000000007e-05 -0.0 2.8600100000000008e-05 -0.00011890367806258925 2.8600200000000008e-05 -0.00011310467725449495 2.860037869822486e-05 -0.00010343719582229614 2.8600852071005926e-05 -8.163664437123026e-05 2.8601514792899416e-05 -5.8610700810396446e-05 2.860236686390533e-05 -3.827824750725529e-05 2.8603408284023676e-05 -2.2741051456998745e-05 2.8604639053254446e-05 -1.2290014582160297e-05 2.8606059171597642e-05 -6.041956833213609e-06 2.8607668639053263e-05 -2.702005326017628e-06 2.860946745562131e-05 -1.0992036099606076e-06 2.8611455621301783e-05 -4.0677425087224927e-07 2.861363313609468e-05 -1.369342616843481e-07 2.861600000000001e-05 -4.1932828487813984e-08 2.861610000000001e-05 -0.0 3.0600000000000005e-05 -0.0 3.0600100000000005e-05 -0.00011890367806258925 3.0600200000000006e-05 -0.00011310467725449495 3.0600378698224856e-05 -0.00010343719582229614 3.060085207100592e-05 -8.163664437123026e-05 3.060151479289941e-05 -5.8610700810396446e-05 3.060236686390533e-05 -3.827824750725529e-05 3.0603408284023674e-05 -2.2741051456998745e-05 3.060463905325444e-05 -1.2290014582160297e-05 3.060605917159764e-05 -6.041956833213609e-06 3.060766863905326e-05 -2.702005326017628e-06 3.060946745562131e-05 -1.0992036099606076e-06 3.061145562130178e-05 -4.0677425087224927e-07 3.061363313609468e-05 -1.369342616843481e-07 3.0616000000000006e-05 -4.1932828487813984e-08 3.0616100000000007e-05 -0.0 3.2600000000000006e-05 -0.0 3.2600100000000007e-05 -0.00011890367806258925 3.260020000000001e-05 -0.00011310467725449495 3.260037869822486e-05 -0.00010343719582229614 3.260085207100592e-05 -8.163664437123026e-05 3.260151479289941e-05 -5.8610700810396446e-05 3.2602366863905334e-05 -3.827824750725529e-05 3.2603408284023675e-05 -2.2741051456998745e-05 3.260463905325444e-05 -1.2290014582160297e-05 3.260605917159764e-05 -6.041956833213609e-06 3.260766863905326e-05 -2.702005326017628e-06 3.260946745562131e-05 -1.0992036099606076e-06 3.261145562130178e-05 -4.0677425087224927e-07 3.261363313609468e-05 -1.369342616843481e-07 3.261600000000001e-05 -4.1932828487813984e-08 3.261610000000001e-05 -0.0 3.460000000000001e-05 -0.0 3.460010000000001e-05 -0.00011890367806258925 3.460020000000001e-05 -0.00011310467725449495 3.460037869822486e-05 -0.00010343719582229614 3.460085207100592e-05 -8.163664437123026e-05 3.460151479289941e-05 -5.8610700810396446e-05 3.4602366863905335e-05 -3.827824750725529e-05 3.4603408284023676e-05 -2.2741051456998745e-05 3.460463905325444e-05 -1.2290014582160297e-05 3.460605917159764e-05 -6.041956833213609e-06 3.460766863905326e-05 -2.702005326017628e-06 3.460946745562131e-05 -1.0992036099606076e-06 3.461145562130178e-05 -4.0677425087224927e-07 3.461363313609468e-05 -1.369342616843481e-07 3.461600000000001e-05 -4.1932828487813984e-08 3.461610000000001e-05 -0.0 7.659999999999998e-05 -0.0 7.660009999999997e-05 -0.0006182991259254641 7.660019999999998e-05 -0.0005881443217233737 7.660037869822483e-05 -0.0005378734182759399 7.66008520710059e-05 -0.00042451055073039733 7.660151479289938e-05 -0.0003047756442140615 7.66023668639053e-05 -0.00019904688703772754 7.660340828402365e-05 -0.00011825346757639348 7.660463905325442e-05 -6.390807582723354e-05 7.660605917159761e-05 -3.1418175532710766e-05 7.660766863905323e-05 -1.4050427695291666e-05 7.660946745562127e-05 -5.715858771795159e-06 7.661145562130176e-05 -2.1152261045356957e-06 7.661363313609465e-05 -7.1205816075861e-07 7.661599999999997e-05 -2.1805070813663269e-07 7.661609999999997e-05 -0.0 7.859999999999997e-05 -0.0 7.860009999999997e-05 -0.0006182991259254641 7.860019999999997e-05 -0.0005881443217233737 7.860037869822482e-05 -0.0005378734182759399 7.860085207100589e-05 -0.00042451055073039733 7.860151479289938e-05 -0.0003047756442140615 7.860236686390529e-05 -0.00019904688703772754 7.860340828402365e-05 -0.00011825346757639348 7.860463905325441e-05 -6.390807582723354e-05 7.860605917159761e-05 -3.1418175532710766e-05 7.860766863905322e-05 -1.4050427695291666e-05 7.860946745562127e-05 -5.715858771795159e-06 7.861145562130175e-05 -2.1152261045356957e-06 7.861363313609465e-05 -7.1205816075861e-07 7.861599999999997e-05 -2.1805070813663269e-07 7.861609999999996e-05 -0.0 8.059999999999997e-05 -0.0 8.060009999999996e-05 -0.0006182991259254641 8.060019999999997e-05 -0.0005881443217233737 8.060037869822482e-05 -0.0005378734182759399 8.060085207100588e-05 -0.00042451055073039733 8.060151479289937e-05 -0.0003047756442140615 8.060236686390529e-05 -0.00019904688703772754 8.060340828402364e-05 -0.00011825346757639348 8.060463905325441e-05 -6.390807582723354e-05 8.06060591715976e-05 -3.1418175532710766e-05 8.060766863905322e-05 -1.4050427695291666e-05 8.060946745562126e-05 -5.715858771795159e-06 8.061145562130175e-05 -2.1152261045356957e-06 8.061363313609464e-05 -7.1205816075861e-07 8.061599999999996e-05 -2.1805070813663269e-07 8.061609999999995e-05 -0.0 8.259999999999996e-05 -0.0 8.260009999999995e-05 -0.0006182991259254641 8.260019999999996e-05 -0.0005881443217233737 8.260037869822481e-05 -0.0005378734182759399 8.260085207100588e-05 -0.00042451055073039733 8.260151479289937e-05 -0.0003047756442140615 8.260236686390528e-05 -0.00019904688703772754 8.260340828402364e-05 -0.00011825346757639348 8.26046390532544e-05 -6.390807582723354e-05 8.26060591715976e-05 -3.1418175532710766e-05 8.260766863905321e-05 -1.4050427695291666e-05 8.260946745562126e-05 -5.715858771795159e-06 8.261145562130174e-05 -2.1152261045356957e-06 8.261363313609464e-05 -7.1205816075861e-07 8.261599999999996e-05 -2.1805070813663269e-07 8.261609999999995e-05 -0.0]
ISEE4 (0 outp) isource type=pwl wave=[0.0 0.0 3.660000000000001e-05 0.0 3.660010000000001e-05 0.00011890367806258925 3.660020000000001e-05 0.00011310467725449495 3.660037869822486e-05 0.00010343719582229614 3.6600852071005924e-05 8.163664437123026e-05 3.6601514792899414e-05 5.8610700810396446e-05 3.6602366863905336e-05 3.827824750725529e-05 3.660340828402368e-05 2.2741051456998745e-05 3.6604639053254444e-05 1.2290014582160297e-05 3.660605917159764e-05 6.041956833213609e-06 3.660766863905326e-05 2.702005326017628e-06 3.660946745562131e-05 1.0992036099606076e-06 3.661145562130178e-05 4.0677425087224927e-07 3.661363313609468e-05 1.369342616843481e-07 3.661600000000001e-05 4.1932828487813984e-08 3.661610000000001e-05 0.0 3.860000000000001e-05 0.0 3.860010000000001e-05 0.00011890367806258925 3.860020000000001e-05 0.00011310467725449495 3.860037869822486e-05 0.00010343719582229614 3.8600852071005925e-05 8.163664437123026e-05 3.8601514792899415e-05 5.8610700810396446e-05 3.860236686390534e-05 3.827824750725529e-05 3.860340828402368e-05 2.2741051456998745e-05 3.8604639053254445e-05 1.2290014582160297e-05 3.8606059171597644e-05 6.041956833213609e-06 3.860766863905326e-05 2.702005326017628e-06 3.860946745562131e-05 1.0992036099606076e-06 3.861145562130178e-05 4.0677425087224927e-07 3.8613633136094684e-05 1.369342616843481e-07 3.861600000000001e-05 4.1932828487813984e-08 3.861610000000001e-05 0.0 4.060000000000001e-05 0.0 4.060010000000001e-05 0.00011890367806258925 4.060020000000001e-05 0.00011310467725449495 4.060037869822486e-05 0.00010343719582229614 4.0600852071005926e-05 8.163664437123026e-05 4.0601514792899416e-05 5.8610700810396446e-05 4.060236686390534e-05 3.827824750725529e-05 4.060340828402368e-05 2.2741051456998745e-05 4.0604639053254446e-05 1.2290014582160297e-05 4.0606059171597645e-05 6.041956833213609e-06 4.0607668639053263e-05 2.702005326017628e-06 4.0609467455621314e-05 1.0992036099606076e-06 4.061145562130178e-05 4.0677425087224927e-07 4.0613633136094685e-05 1.369342616843481e-07 4.061600000000001e-05 4.1932828487813984e-08 4.061610000000001e-05 0.0 4.260000000000001e-05 0.0 4.260010000000001e-05 0.00011890367806258925 4.260020000000001e-05 0.00011310467725449495 4.2600378698224864e-05 0.00010343719582229614 4.260085207100593e-05 8.163664437123026e-05 4.260151479289942e-05 5.8610700810396446e-05 4.260236686390534e-05 3.827824750725529e-05 4.260340828402368e-05 2.2741051456998745e-05 4.260463905325445e-05 1.2290014582160297e-05 4.2606059171597647e-05 6.041956833213609e-06 4.2607668639053265e-05 2.702005326017628e-06 4.2609467455621315e-05 1.0992036099606076e-06 4.2611455621301784e-05 4.0677425087224927e-07 4.2613633136094686e-05 1.369342616843481e-07 4.2616000000000013e-05 4.1932828487813984e-08 4.2616100000000014e-05 0.0 8.459999999999996e-05 0.0 8.460009999999995e-05 0.0006182991259254641 8.460019999999996e-05 0.0005881443217233737 8.460037869822481e-05 0.0005378734182759399 8.460085207100587e-05 0.00042451055073039733 8.460151479289936e-05 0.0003047756442140615 8.460236686390528e-05 0.00019904688703772754 8.460340828402363e-05 0.00011825346757639348 8.46046390532544e-05 6.390807582723354e-05 8.460605917159759e-05 3.1418175532710766e-05 8.460766863905321e-05 1.4050427695291666e-05 8.460946745562125e-05 5.715858771795159e-06 8.461145562130173e-05 2.1152261045356957e-06 8.461363313609463e-05 7.1205816075861e-07 8.461599999999995e-05 2.1805070813663269e-07 8.461609999999994e-05 0.0 8.659999999999995e-05 0.0 8.660009999999994e-05 0.0006182991259254641 8.660019999999995e-05 0.0005881443217233737 8.66003786982248e-05 0.0005378734182759399 8.660085207100587e-05 0.00042451055073039733 8.660151479289936e-05 0.0003047756442140615 8.660236686390527e-05 0.00019904688703772754 8.660340828402363e-05 0.00011825346757639348 8.660463905325439e-05 6.390807582723354e-05 8.660605917159758e-05 3.1418175532710766e-05 8.66076686390532e-05 1.4050427695291666e-05 8.660946745562125e-05 5.715858771795159e-06 8.661145562130173e-05 2.1152261045356957e-06 8.661363313609462e-05 7.1205816075861e-07 8.661599999999994e-05 2.1805070813663269e-07 8.661609999999994e-05 0.0 8.859999999999994e-05 0.0 8.860009999999994e-05 0.0006182991259254641 8.860019999999994e-05 0.0005881443217233737 8.86003786982248e-05 0.0005378734182759399 8.860085207100586e-05 0.00042451055073039733 8.860151479289935e-05 0.0003047756442140615 8.860236686390527e-05 0.00019904688703772754 8.860340828402362e-05 0.00011825346757639348 8.860463905325439e-05 6.390807582723354e-05 8.860605917159758e-05 3.1418175532710766e-05 8.86076686390532e-05 1.4050427695291666e-05 8.860946745562124e-05 5.715858771795159e-06 8.861145562130172e-05 2.1152261045356957e-06 8.861363313609462e-05 7.1205816075861e-07 8.861599999999994e-05 2.1805070813663269e-07 8.861609999999993e-05 0.0 9.059999999999994e-05 0.0 9.060009999999993e-05 0.0006182991259254641 9.060019999999994e-05 0.0005881443217233737 9.060037869822479e-05 0.0005378734182759399 9.060085207100585e-05 0.00042451055073039733 9.060151479289934e-05 0.0003047756442140615 9.060236686390526e-05 0.00019904688703772754 9.060340828402361e-05 0.00011825346757639348 9.060463905325438e-05 6.390807582723354e-05 9.060605917159757e-05 3.1418175532710766e-05 9.060766863905319e-05 1.4050427695291666e-05 9.060946745562123e-05 5.715858771795159e-06 9.061145562130172e-05 2.1152261045356957e-06 9.061363313609461e-05 7.1205816075861e-07 9.061599999999993e-05 2.1805070813663269e-07 9.061609999999993e-05 0.0]
ISEE5 (0 outp) isource type=pwl wave=[0.0 0.0 4.4600000000000013e-05 -0.0 4.4600100000000014e-05 -0.00011890367806258925 4.4600200000000014e-05 -0.00011310467725449495 4.4600378698224865e-05 -0.00010343719582229614 4.460085207100593e-05 -8.163664437123026e-05 4.460151479289942e-05 -5.8610700810396446e-05 4.460236686390534e-05 -3.827824750725529e-05 4.460340828402368e-05 -2.2741051456998745e-05 4.460463905325445e-05 -1.2290014582160297e-05 4.460605917159765e-05 -6.041956833213609e-06 4.4607668639053266e-05 -2.702005326017628e-06 4.4609467455621316e-05 -1.0992036099606076e-06 4.4611455621301786e-05 -4.0677425087224927e-07 4.461363313609469e-05 -1.369342616843481e-07 4.4616000000000015e-05 -4.1932828487813984e-08 4.4616100000000015e-05 -0.0 4.6600000000000015e-05 -0.0 4.6600100000000015e-05 -0.00011890367806258925 4.6600200000000015e-05 -0.00011310467725449495 4.6600378698224866e-05 -0.00010343719582229614 4.660085207100593e-05 -8.163664437123026e-05 4.660151479289942e-05 -5.8610700810396446e-05 4.660236686390534e-05 -3.827824750725529e-05 4.660340828402368e-05 -2.2741051456998745e-05 4.660463905325445e-05 -1.2290014582160297e-05 4.660605917159765e-05 -6.041956833213609e-06 4.660766863905327e-05 -2.702005326017628e-06 4.660946745562132e-05 -1.0992036099606076e-06 4.661145562130179e-05 -4.0677425087224927e-07 4.661363313609469e-05 -1.369342616843481e-07 4.6616000000000016e-05 -4.1932828487813984e-08 4.6616100000000016e-05 -0.0 4.8600000000000016e-05 -0.0 4.8600100000000016e-05 -0.00011890367806258925 4.8600200000000016e-05 -0.00011310467725449495 4.860037869822487e-05 -0.00010343719582229614 4.860085207100593e-05 -8.163664437123026e-05 4.860151479289942e-05 -5.8610700810396446e-05 4.860236686390534e-05 -3.827824750725529e-05 4.8603408284023684e-05 -2.2741051456998745e-05 4.860463905325445e-05 -1.2290014582160297e-05 4.860605917159765e-05 -6.041956833213609e-06 4.860766863905327e-05 -2.702005326017628e-06 4.860946745562132e-05 -1.0992036099606076e-06 4.861145562130179e-05 -4.0677425087224927e-07 4.861363313609469e-05 -1.369342616843481e-07 4.861600000000002e-05 -4.1932828487813984e-08 4.861610000000002e-05 -0.0 5.060000000000002e-05 -0.0 5.060010000000002e-05 -0.00011890367806258925 5.060020000000002e-05 -0.00011310467725449495 5.060037869822487e-05 -0.00010343719582229614 5.060085207100593e-05 -8.163664437123026e-05 5.060151479289942e-05 -5.8610700810396446e-05 5.0602366863905344e-05 -3.827824750725529e-05 5.0603408284023685e-05 -2.2741051456998745e-05 5.060463905325445e-05 -1.2290014582160297e-05 5.060605917159765e-05 -6.041956833213609e-06 5.060766863905327e-05 -2.702005326017628e-06 5.060946745562132e-05 -1.0992036099606076e-06 5.061145562130179e-05 -4.0677425087224927e-07 5.061363313609469e-05 -1.369342616843481e-07 5.061600000000002e-05 -4.1932828487813984e-08 5.061610000000002e-05 -0.0 9.259999999999993e-05 -0.0 9.260009999999993e-05 -0.0006182991259254641 9.260019999999993e-05 -0.0005881443217233737 9.260037869822478e-05 -0.0005378734182759399 9.260085207100585e-05 -0.00042451055073039733 9.260151479289934e-05 -0.0003047756442140615 9.260236686390525e-05 -0.00019904688703772754 9.260340828402361e-05 -0.00011825346757639348 9.260463905325438e-05 -6.390807582723354e-05 9.260605917159757e-05 -3.1418175532710766e-05 9.260766863905319e-05 -1.4050427695291666e-05 9.260946745562123e-05 -5.715858771795159e-06 9.261145562130171e-05 -2.1152261045356957e-06 9.261363313609461e-05 -7.1205816075861e-07 9.261599999999993e-05 -2.1805070813663269e-07 9.261609999999992e-05 -0.0 9.459999999999993e-05 -0.0 9.460009999999992e-05 -0.0006182991259254641 9.460019999999993e-05 -0.0005881443217233737 9.460037869822478e-05 -0.0005378734182759399 9.460085207100584e-05 -0.00042451055073039733 9.460151479289933e-05 -0.0003047756442140615 9.460236686390525e-05 -0.00019904688703772754 9.46034082840236e-05 -0.00011825346757639348 9.460463905325437e-05 -6.390807582723354e-05 9.460605917159756e-05 -3.1418175532710766e-05 9.460766863905318e-05 -1.4050427695291666e-05 9.460946745562122e-05 -5.715858771795159e-06 9.46114556213017e-05 -2.1152261045356957e-06 9.46136331360946e-05 -7.1205816075861e-07 9.461599999999992e-05 -2.1805070813663269e-07 9.461609999999992e-05 -0.0 9.659999999999992e-05 -0.0 9.660009999999992e-05 -0.0006182991259254641 9.660019999999992e-05 -0.0005881443217233737 9.660037869822477e-05 -0.0005378734182759399 9.660085207100584e-05 -0.00042451055073039733 9.660151479289933e-05 -0.0003047756442140615 9.660236686390524e-05 -0.00019904688703772754 9.66034082840236e-05 -0.00011825346757639348 9.660463905325436e-05 -6.390807582723354e-05 9.660605917159756e-05 -3.1418175532710766e-05 9.660766863905317e-05 -1.4050427695291666e-05 9.660946745562122e-05 -5.715858771795159e-06 9.66114556213017e-05 -2.1152261045356957e-06 9.66136331360946e-05 -7.1205816075861e-07 9.661599999999992e-05 -2.1805070813663269e-07 9.661609999999991e-05 -0.0 9.859999999999992e-05 -0.0 9.860009999999991e-05 -0.0006182991259254641 9.860019999999992e-05 -0.0005881443217233737 9.860037869822477e-05 -0.0005378734182759399 9.860085207100583e-05 -0.00042451055073039733 9.860151479289932e-05 -0.0003047756442140615 9.860236686390524e-05 -0.00019904688703772754 9.860340828402359e-05 -0.00011825346757639348 9.860463905325436e-05 -6.390807582723354e-05 9.860605917159755e-05 -3.1418175532710766e-05 9.860766863905317e-05 -1.4050427695291666e-05 9.860946745562121e-05 -5.715858771795159e-06 9.86114556213017e-05 -2.1152261045356957e-06 9.861363313609459e-05 -7.1205816075861e-07 9.861599999999991e-05 -2.1805070813663269e-07 9.86160999999999e-05 -0.0]
tr1 tran stop=9.999999999999991e-05 maxstep=5e-10 errpreset=moderate
