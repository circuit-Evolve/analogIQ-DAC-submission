// Golden sizing netlist (curator 2026-10-28): the benchmark DUT subckt with its parameter defaults set to
// the golden design (golden_design.json), taken from the verified run's job NN_T27_S1p00/sar_dynamic_v1.
// The DUT subckt and its parameter values are the same in every job of that run (only the testbench changes).
// Instance line of that run: XDUT (b_BP_CP11a b_BP_CP11b b_BP_CP10a b_BP_CP10b b_BP_CP9a b_BP_CP9b b_BP_CP8a b_BP_CP8b b_BP_CP7a b_BP_CP7b b_BP_CP6a b_BP_CP6b b_BP_CP5a b_BP_CP5b b_BP_CP5ac b_BP_CP5bc b_BP_CP4 b_BP_CP3 b_BP_CP2 b...
// Testbench-level variables (bias sources, operating levels) are in golden_design.json and testbench decks.
// Generated by analogiq from final.scs (sha256 18f0475808958dcf).
// Connectivity and device models are unchanged except for the listed transformations:
//   - M1: junction geometry ad/as/pd/ps rewritten in terms of the bound width (area = Lj*W, perimeter = 2*W + c; Lj and c from the netlist)
//   - M2: junction geometry ad/as/pd/ps rewritten in terms of the bound width (area = Lj*W, perimeter = 2*W + c; Lj and c from the netlist)
//   - M3: junction geometry ad/as/pd/ps rewritten in terms of the bound width (area = Lj*W, perimeter = 2*W + c; Lj and c from the netlist)
//   - M4: junction geometry ad/as/pd/ps rewritten in terms of the bound width (area = Lj*W, perimeter = 2*W + c; Lj and c from the netlist)
//   - M5: junction geometry ad/as/pd/ps rewritten in terms of the bound width (area = Lj*W, perimeter = 2*W + c; Lj and c from the netlist)
//   - M6: junction geometry ad/as/pd/ps rewritten in terms of the bound width (area = Lj*W, perimeter = 2*W + c; Lj and c from the netlist)
//   - MPH_L: junction geometry ad/as/pd/ps rewritten in terms of the bound width (area = Lj*W, perimeter = 2*W + c; Lj and c from the netlist)
//   - MNR_L: junction geometry ad/as/pd/ps rewritten in terms of the bound width (area = Lj*W, perimeter = 2*W + c; Lj and c from the netlist)
//   - MPL_L: junction geometry ad/as/pd/ps rewritten in terms of the bound width (area = Lj*W, perimeter = 2*W + c; Lj and c from the netlist)
//   - MNL_L: junction geometry ad/as/pd/ps rewritten in terms of the bound width (area = Lj*W, perimeter = 2*W + c; Lj and c from the netlist)
//   - MND_L: junction geometry ad/as/pd/ps rewritten in terms of the bound width (area = Lj*W, perimeter = 2*W + c; Lj and c from the netlist)
//   - MPH_R: junction geometry ad/as/pd/ps rewritten in terms of the bound width (area = Lj*W, perimeter = 2*W + c; Lj and c from the netlist)
//   - MNR_R: junction geometry ad/as/pd/ps rewritten in terms of the bound width (area = Lj*W, perimeter = 2*W + c; Lj and c from the netlist)
//   - MPL_R: junction geometry ad/as/pd/ps rewritten in terms of the bound width (area = Lj*W, perimeter = 2*W + c; Lj and c from the netlist)
//   - MNL_R: junction geometry ad/as/pd/ps rewritten in terms of the bound width (area = Lj*W, perimeter = 2*W + c; Lj and c from the netlist)
//   - MND_R: junction geometry ad/as/pd/ps rewritten in terms of the bound width (area = Lj*W, perimeter = 2*W + c; Lj and c from the netlist)
//   - MP_COP: junction geometry ad/as/pd/ps rewritten in terms of the bound width (area = Lj*W, perimeter = 2*W + c; Lj and c from the netlist)
//   - MN_COP: junction geometry ad/as/pd/ps rewritten in terms of the bound width (area = Lj*W, perimeter = 2*W + c; Lj and c from the netlist)
//   - MP_CON: junction geometry ad/as/pd/ps rewritten in terms of the bound width (area = Lj*W, perimeter = 2*W + c; Lj and c from the netlist)
//   - MN_CON: junction geometry ad/as/pd/ps rewritten in terms of the bound width (area = Lj*W, perimeter = 2*W + c; Lj and c from the netlist)
//   - widths bound to sizing variables on fold-capable devices are folded symbolically into ceil(W/max) fingers of W/ceil(W/max) (per-device max [1e-05] m): M1, M2, M3, M4, M5, M6, MND_L, MND_R, MNL_L, MNL_R, MNR_L, MNR_R, MN_CON, MN_COP, MPH_L, MPH_R, MPL_L, MPL_R, MP_CON, MP_COP
subckt sar24_liang_dut (BP_CP11a BP_CP11b BP_CP10a BP_CP10b BP_CP9a BP_CP9b BP_CP8a BP_CP8b BP_CP7a BP_CP7b BP_CP6a BP_CP6b BP_CP5a BP_CP5b BP_CP5ac BP_CP5bc BP_CP4 BP_CP3 BP_CP2 BP_CP1 VXP_MSB VXP_MID VXP BP_CN11a BP_CN11b BP_CN10a BP_CN10b BP_CN9a BP_CN9b BP_CN8a BP_CN8b BP_CN7a BP_CN7b BP_CN6a BP_CN6b BP_CN5a BP_CN5b BP_CN5ac BP_CN5bc BP_CN4 BP_CN3 BP_CN2 BP_CN1 VXN_MSB VXN_MID VXN VDD VSS CKC COP CON)
parameters W_IN=6e-06 L_IN=1.8e-07 W_PC=4e-06 L_PC=1.8e-07 W_TL=4e-06 L_TL=1.8e-07 W_M6=1e-06 L_M6=1.8e-07 W_PH=4e-06 L_PH=1.8e-07 W_NR=2e-06 L_NR=1.8e-07 W_PL=4e-06 L_PL=1.8e-07 W_NL=2e-06 L_NL=1.8e-07 W_ND=2e-06 L_ND=1.8e-07 W_OP=4e-06 L_OP=1.8e-07 W_ON=2e-06 L_ON=1.8e-07 CU=1.6e-14
M1 (VON VXP VCS VSS) nmos1 w=(W_IN/max(1, W_IN/1e-05)) l=L_IN m=max(1, W_IN/1e-05) ad=(6e-07*((W_IN/max(1, W_IN/1e-05)))) as=(6e-07*((W_IN/max(1, W_IN/1e-05)))) pd=max(2*((W_IN/max(1, W_IN/1e-05)))+(1.1999999999999987e-06),0) ps=max(2*((W_IN/max(1, W_IN/1e-05)))+(1.1999999999999987e-06),0)
M2 (VOP VXN VCS VSS) nmos1 w=(W_IN/max(1, W_IN/1e-05)) l=L_IN m=max(1, W_IN/1e-05) ad=(6e-07*((W_IN/max(1, W_IN/1e-05)))) as=(6e-07*((W_IN/max(1, W_IN/1e-05)))) pd=max(2*((W_IN/max(1, W_IN/1e-05)))+(1.1999999999999987e-06),0) ps=max(2*((W_IN/max(1, W_IN/1e-05)))+(1.1999999999999987e-06),0)
M3 (VON CKC VDD VDD) pmos1 w=(W_PC/max(1, W_PC/1e-05)) l=L_PC m=max(1, W_PC/1e-05) ad=(6e-07*((W_PC/max(1, W_PC/1e-05)))) as=(6e-07*((W_PC/max(1, W_PC/1e-05)))) pd=max(2*((W_PC/max(1, W_PC/1e-05)))+(1.1999999999999987e-06),0) ps=max(2*((W_PC/max(1, W_PC/1e-05)))+(1.1999999999999987e-06),0)
M4 (VOP CKC VDD VDD) pmos1 w=(W_PC/max(1, W_PC/1e-05)) l=L_PC m=max(1, W_PC/1e-05) ad=(6e-07*((W_PC/max(1, W_PC/1e-05)))) as=(6e-07*((W_PC/max(1, W_PC/1e-05)))) pd=max(2*((W_PC/max(1, W_PC/1e-05)))+(1.1999999999999987e-06),0) ps=max(2*((W_PC/max(1, W_PC/1e-05)))+(1.1999999999999987e-06),0)
M5 (VCS CKC VSS VSS) nmos1 w=(W_TL/max(1, W_TL/1e-05)) l=L_TL m=max(1, W_TL/1e-05) ad=(6e-07*((W_TL/max(1, W_TL/1e-05)))) as=(6e-07*((W_TL/max(1, W_TL/1e-05)))) pd=max(2*((W_TL/max(1, W_TL/1e-05)))+(1.1999999999999987e-06),0) ps=max(2*((W_TL/max(1, W_TL/1e-05)))+(1.1999999999999987e-06),0)
M6 (VCS CKC VDD VDD) pmos1 w=(W_M6/max(1, W_M6/1e-05)) l=L_M6 m=max(1, W_M6/1e-05) ad=(6.000000000000001e-07*((W_M6/max(1, W_M6/1e-05)))) as=(6.000000000000001e-07*((W_M6/max(1, W_M6/1e-05)))) pd=max(2*((W_M6/max(1, W_M6/1e-05)))+(1.2e-06),0) ps=max(2*((W_M6/max(1, W_M6/1e-05)))+(1.2e-06),0)
MPH_L (HL VOP VDD VDD) pmos1 w=(W_PH/max(1, W_PH/1e-05)) l=L_PH m=max(1, W_PH/1e-05) ad=(6.000000000000001e-07*((W_PH/max(1, W_PH/1e-05)))) as=(6.000000000000001e-07*((W_PH/max(1, W_PH/1e-05)))) pd=max(2*((W_PH/max(1, W_PH/1e-05)))+(1.2e-06),0) ps=max(2*((W_PH/max(1, W_PH/1e-05)))+(1.2e-06),0)
MNR_L (HL VOP VSS VSS) nmos1 w=(W_NR/max(1, W_NR/1e-05)) l=L_NR m=max(1, W_NR/1e-05) ad=(6.000000000000001e-07*((W_NR/max(1, W_NR/1e-05)))) as=(6.000000000000001e-07*((W_NR/max(1, W_NR/1e-05)))) pd=max(2*((W_NR/max(1, W_NR/1e-05)))+(1.2e-06),0) ps=max(2*((W_NR/max(1, W_NR/1e-05)))+(1.2e-06),0)
MPL_L (QL QR HL VDD) pmos1 w=(W_PL/max(1, W_PL/1e-05)) l=L_PL m=max(1, W_PL/1e-05) ad=(6.000000000000001e-07*((W_PL/max(1, W_PL/1e-05)))) as=(6.000000000000001e-07*((W_PL/max(1, W_PL/1e-05)))) pd=max(2*((W_PL/max(1, W_PL/1e-05)))+(1.2e-06),0) ps=max(2*((W_PL/max(1, W_PL/1e-05)))+(1.2e-06),0)
MNL_L (QL QR VSS VSS) nmos1 w=(W_NL/max(1, W_NL/1e-05)) l=L_NL m=max(1, W_NL/1e-05) ad=(6.000000000000001e-07*((W_NL/max(1, W_NL/1e-05)))) as=(6.000000000000001e-07*((W_NL/max(1, W_NL/1e-05)))) pd=max(2*((W_NL/max(1, W_NL/1e-05)))+(1.2e-06),0) ps=max(2*((W_NL/max(1, W_NL/1e-05)))+(1.2e-06),0)
MND_L (QL VOP VSS VSS) nmos1 w=(W_ND/max(1, W_ND/1e-05)) l=L_ND m=max(1, W_ND/1e-05) ad=(6.000000000000001e-07*((W_ND/max(1, W_ND/1e-05)))) as=(6.000000000000001e-07*((W_ND/max(1, W_ND/1e-05)))) pd=max(2*((W_ND/max(1, W_ND/1e-05)))+(1.2e-06),0) ps=max(2*((W_ND/max(1, W_ND/1e-05)))+(1.2e-06),0)
MPH_R (HR VON VDD VDD) pmos1 w=(W_PH/max(1, W_PH/1e-05)) l=L_PH m=max(1, W_PH/1e-05) ad=(6.000000000000001e-07*((W_PH/max(1, W_PH/1e-05)))) as=(6.000000000000001e-07*((W_PH/max(1, W_PH/1e-05)))) pd=max(2*((W_PH/max(1, W_PH/1e-05)))+(1.2e-06),0) ps=max(2*((W_PH/max(1, W_PH/1e-05)))+(1.2e-06),0)
MNR_R (HR VON VSS VSS) nmos1 w=(W_NR/max(1, W_NR/1e-05)) l=L_NR m=max(1, W_NR/1e-05) ad=(6.000000000000001e-07*((W_NR/max(1, W_NR/1e-05)))) as=(6.000000000000001e-07*((W_NR/max(1, W_NR/1e-05)))) pd=max(2*((W_NR/max(1, W_NR/1e-05)))+(1.2e-06),0) ps=max(2*((W_NR/max(1, W_NR/1e-05)))+(1.2e-06),0)
MPL_R (QR QL HR VDD) pmos1 w=(W_PL/max(1, W_PL/1e-05)) l=L_PL m=max(1, W_PL/1e-05) ad=(6.000000000000001e-07*((W_PL/max(1, W_PL/1e-05)))) as=(6.000000000000001e-07*((W_PL/max(1, W_PL/1e-05)))) pd=max(2*((W_PL/max(1, W_PL/1e-05)))+(1.2e-06),0) ps=max(2*((W_PL/max(1, W_PL/1e-05)))+(1.2e-06),0)
MNL_R (QR QL VSS VSS) nmos1 w=(W_NL/max(1, W_NL/1e-05)) l=L_NL m=max(1, W_NL/1e-05) ad=(6.000000000000001e-07*((W_NL/max(1, W_NL/1e-05)))) as=(6.000000000000001e-07*((W_NL/max(1, W_NL/1e-05)))) pd=max(2*((W_NL/max(1, W_NL/1e-05)))+(1.2e-06),0) ps=max(2*((W_NL/max(1, W_NL/1e-05)))+(1.2e-06),0)
MND_R (QR VON VSS VSS) nmos1 w=(W_ND/max(1, W_ND/1e-05)) l=L_ND m=max(1, W_ND/1e-05) ad=(6.000000000000001e-07*((W_ND/max(1, W_ND/1e-05)))) as=(6.000000000000001e-07*((W_ND/max(1, W_ND/1e-05)))) pd=max(2*((W_ND/max(1, W_ND/1e-05)))+(1.2e-06),0) ps=max(2*((W_ND/max(1, W_ND/1e-05)))+(1.2e-06),0)
MP_COP (COP QL VDD VDD) pmos1 w=(W_OP/max(1, W_OP/1e-05)) l=L_OP m=max(1, W_OP/1e-05) ad=(6.000000000000001e-07*((W_OP/max(1, W_OP/1e-05)))) as=(6.000000000000001e-07*((W_OP/max(1, W_OP/1e-05)))) pd=max(2*((W_OP/max(1, W_OP/1e-05)))+(1.2e-06),0) ps=max(2*((W_OP/max(1, W_OP/1e-05)))+(1.2e-06),0)
MN_COP (COP QL VSS VSS) nmos1 w=(W_ON/max(1, W_ON/1e-05)) l=L_ON m=max(1, W_ON/1e-05) ad=(6.000000000000001e-07*((W_ON/max(1, W_ON/1e-05)))) as=(6.000000000000001e-07*((W_ON/max(1, W_ON/1e-05)))) pd=max(2*((W_ON/max(1, W_ON/1e-05)))+(1.2e-06),0) ps=max(2*((W_ON/max(1, W_ON/1e-05)))+(1.2e-06),0)
MP_CON (CON QR VDD VDD) pmos1 w=(W_OP/max(1, W_OP/1e-05)) l=L_OP m=max(1, W_OP/1e-05) ad=(6.000000000000001e-07*((W_OP/max(1, W_OP/1e-05)))) as=(6.000000000000001e-07*((W_OP/max(1, W_OP/1e-05)))) pd=max(2*((W_OP/max(1, W_OP/1e-05)))+(1.2e-06),0) ps=max(2*((W_OP/max(1, W_OP/1e-05)))+(1.2e-06),0)
MN_CON (CON QR VSS VSS) nmos1 w=(W_ON/max(1, W_ON/1e-05)) l=L_ON m=max(1, W_ON/1e-05) ad=(6.000000000000001e-07*((W_ON/max(1, W_ON/1e-05)))) as=(6.000000000000001e-07*((W_ON/max(1, W_ON/1e-05)))) pd=max(2*((W_ON/max(1, W_ON/1e-05)))+(1.2e-06),0) ps=max(2*((W_ON/max(1, W_ON/1e-05)))+(1.2e-06),0)
CP11a (VXP_MSB BP_CP11a) capacitor c=(64*CU)
CP11b (VXP_MSB BP_CP11b) capacitor c=(64*CU)
CP10a (VXP_MSB BP_CP10a) capacitor c=(32*CU)
CP10b (VXP_MSB BP_CP10b) capacitor c=(32*CU)
CP9a (VXP_MID BP_CP9a) capacitor c=(16*CU)
CP9b (VXP_MID BP_CP9b) capacitor c=(16*CU)
CP8a (VXP_MID BP_CP8a) capacitor c=(8*CU)
CP8b (VXP_MID BP_CP8b) capacitor c=(8*CU)
CP7a (VXP BP_CP7a) capacitor c=(4*CU)
CP7b (VXP BP_CP7b) capacitor c=(4*CU)
CP6a (VXP BP_CP6a) capacitor c=(2*CU)
CP6b (VXP BP_CP6b) capacitor c=(2*CU)
CP5a (VXP BP_CP5a) capacitor c=CU
CP5b (VXP BP_CP5b) capacitor c=CU
CP5ac (VXP BP_CP5ac) capacitor c=CU
CP5bc (VXP BP_CP5bc) capacitor c=CU
CP4 (VXP BP_CP4) capacitor c=CU
CP3 (VXP BP_CP3) capacitor c=(4*CU)
CP2 (VXP BP_CP2) capacitor c=(2*CU)
CP1 (VXP BP_CP1) capacitor c=CU
CN11a (VXN_MSB BP_CN11a) capacitor c=(64*CU)
CN11b (VXN_MSB BP_CN11b) capacitor c=(64*CU)
CN10a (VXN_MSB BP_CN10a) capacitor c=(32*CU)
CN10b (VXN_MSB BP_CN10b) capacitor c=(32*CU)
CN9a (VXN_MID BP_CN9a) capacitor c=(16*CU)
CN9b (VXN_MID BP_CN9b) capacitor c=(16*CU)
CN8a (VXN_MID BP_CN8a) capacitor c=(8*CU)
CN8b (VXN_MID BP_CN8b) capacitor c=(8*CU)
CN7a (VXN BP_CN7a) capacitor c=(4*CU)
CN7b (VXN BP_CN7b) capacitor c=(4*CU)
CN6a (VXN BP_CN6a) capacitor c=(2*CU)
CN6b (VXN BP_CN6b) capacitor c=(2*CU)
CN5a (VXN BP_CN5a) capacitor c=CU
CN5b (VXN BP_CN5b) capacitor c=CU
CN5ac (VXN BP_CN5ac) capacitor c=CU
CN5bc (VXN BP_CN5bc) capacitor c=CU
CN4 (VXN BP_CN4) capacitor c=CU
CN3 (VXN BP_CN3) capacitor c=(4*CU)
CN2 (VXN BP_CN2) capacitor c=(2*CU)
CN1 (VXN BP_CN1) capacitor c=CU
ends sar24_liang_dut
