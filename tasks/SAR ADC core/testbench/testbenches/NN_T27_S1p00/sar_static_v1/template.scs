// analogiq 0.1.0 testbench - generated, do not edit
// task sar24_liang_task_001  topology sar24_liang
// recipe sar_static_v1 v1  condition NN_T27_S1p00 (models NN, 27 C, supply 1.8 V)
// request sar24_liang_task_001__plan  candidate 3e435dc5a9c9f4e7
// execution profile search_full
simulator lang=spectre
global 0
include "<CADENCE_SHARED>/FOUNDRY/analog/180nm/models/spectre/gpdk.scs" section=NN
include "dut.scs"
ahdl_include "sar_seq.va"

parameters vsup=1.8 vcm=0.9
// Supply (its power is a metric; the sequencer is fixed instrumentation, see sar_seq.va).
VSUP (vdd 0) vsource dc=vsup
VNEG (vss 0) vsource dc=0
// Input sources (differential, common mode vcm).
VINP (inp 0) vsource type=pwl wave=[0.0 0.06483664772727271 9e-08 0.06483664772727271 1e-07 0.1076655375874126 1.8999999999999998e-07 0.1076655375874126 2e-07 0.15049442744755248 2.9e-07 0.15049442744755248 3e-07 0.19332331730769237 3.8999999999999997e-07 0.19332331730769237 4e-07 0.23615220716783214 4.9e-07 0.23615220716783214 5e-07 0.278981097027972 5.9e-07 0.278981097027972 6e-07 0.3218099868881119 6.9e-07 0.3218099868881119 7e-07 0.3646388767482517 7.9e-07 0.3646388767482517 8e-07 0.4074677666083916 8.9e-07 0.4074677666083916 9e-07 0.4502966564685315 9.9e-07 0.4502966564685315 1e-06 0.49312554632867134 1.09e-06 0.49312554632867134 1.1e-06 0.5359544361888112 1.19e-06 0.5359544361888112 1.2e-06 0.5787833260489511 1.29e-06 0.5787833260489511 1.2999999999999998e-06 0.621612215909091 1.3899999999999998e-06 0.621612215909091 1.4e-06 0.6644411057692308 1.49e-06 0.6644411057692308 1.5e-06 0.7072699956293707 1.59e-06 0.7072699956293707 1.6e-06 0.7500988854895105 1.69e-06 0.7500988854895105 1.6999999999999998e-06 0.7929277753496504 1.7899999999999998e-06 0.7929277753496504 1.8e-06 0.8357566652097903 1.89e-06 0.8357566652097903 1.9e-06 0.8785855550699301 1.99e-06 0.8785855550699301 2e-06 0.92141444493007 2.09e-06 0.92141444493007 2.1e-06 0.9642433347902098 2.1899999999999998e-06 0.9642433347902098 2.2e-06 1.0070722246503498 2.29e-06 1.0070722246503498 2.3e-06 1.0499011145104897 2.39e-06 1.0499011145104897 2.4e-06 1.0927300043706296 2.49e-06 1.0927300043706296 2.4999999999999998e-06 1.1355588942307695 2.5899999999999998e-06 1.1355588942307695 2.5999999999999997e-06 1.1783877840909094 2.6899999999999997e-06 1.1783877840909094 2.7e-06 1.2212166739510488 2.79e-06 1.2212166739510488 2.8e-06 1.2640455638111887 2.89e-06 1.2640455638111887 2.8999999999999998e-06 1.3068744536713286 2.9899999999999997e-06 1.3068744536713286 3e-06 1.3497033435314685 3.09e-06 1.3497033435314685 3.1e-06 1.3925322333916084 3.19e-06 1.3925322333916084 3.2e-06 1.4353611232517482 3.29e-06 1.4353611232517482 3.2999999999999997e-06 1.4781900131118881 3.3899999999999997e-06 1.4781900131118881 3.3999999999999996e-06 1.521018902972028 3.4899999999999996e-06 1.521018902972028 3.5e-06 1.563847792832168 3.59e-06 1.563847792832168 3.6e-06 1.6066766826923078 3.69e-06 1.6066766826923078 3.6999999999999997e-06 1.6495055725524477 3.7899999999999997e-06 1.6495055725524477 3.8e-06 1.6923344624125876 3.89e-06 1.6923344624125876 3.9e-06 1.7351633522727274 3.99e-06 1.7351633522727274 4e-06 0.9031960227272727 4.09e-06 0.9031960227272727 4.1e-06 0.9036221590909091 4.19e-06 0.9036221590909091 4.2e-06 0.8968039772727273 4.29e-06 0.8968039772727273 4.2999999999999995e-06 0.8963778409090909 4.3899999999999995e-06 0.8963778409090909 4.4e-06 0.9134232954545455 4.49e-06 0.9134232954545455 4.5e-06 0.9138494318181818 4.59e-06 0.9138494318181818 4.6e-06 0.8865767045454546 4.69e-06 0.8865767045454546 4.7e-06 0.8861505681818183 4.79e-06 0.8861505681818183 4.8e-06 0.9543323863636364 4.89e-06 0.9543323863636364 4.9e-06 0.9547585227272728 4.99e-06 0.9547585227272728 4.9999999999999996e-06 0.8456676136363637 5.0899999999999995e-06 0.8456676136363637 5.0999999999999995e-06 0.8452414772727272 5.1899999999999994e-06 0.8452414772727272 5.199999999999999e-06 1.0088778409090908 5.289999999999999e-06 1.0088778409090908 5.3e-06 1.0093039772727272 5.39e-06 1.0093039772727272 5.4e-06 0.7911221590909091 5.49e-06 0.7911221590909091 5.5e-06 0.7906960227272728 5.59e-06 0.7906960227272728 5.6e-06 1.11796875 5.69e-06 1.11796875 5.7e-06 1.1183948863636364 5.79e-06 1.1183948863636364 5.7999999999999995e-06 0.68203125 5.8899999999999995e-06 0.68203125 5.899999999999999e-06 0.6816051136363637 5.989999999999999e-06 0.6816051136363637 6e-06 1.3361505681818182 6.09e-06 1.3361505681818182 6.1e-06 1.3365767045454546 6.19e-06 1.3365767045454546 6.2e-06 0.4638494318181818 6.29e-06 0.4638494318181818 6.3e-06 0.46342329545454547 6.39e-06 0.46342329545454547 6.4e-06 0.46342329545454547]
VINN (inn 0) vsource type=pwl wave=[0.0 1.7351633522727274 9e-08 1.7351633522727274 1e-07 1.6923344624125876 1.8999999999999998e-07 1.6923344624125876 2e-07 1.6495055725524477 2.9e-07 1.6495055725524477 3e-07 1.6066766826923078 3.8999999999999997e-07 1.6066766826923078 4e-07 1.563847792832168 4.9e-07 1.563847792832168 5e-07 1.521018902972028 5.9e-07 1.521018902972028 6e-07 1.4781900131118881 6.9e-07 1.4781900131118881 7e-07 1.4353611232517482 7.9e-07 1.4353611232517482 8e-07 1.3925322333916084 8.9e-07 1.3925322333916084 9e-07 1.3497033435314685 9.9e-07 1.3497033435314685 1e-06 1.3068744536713286 1.09e-06 1.3068744536713286 1.1e-06 1.2640455638111887 1.19e-06 1.2640455638111887 1.2e-06 1.2212166739510488 1.29e-06 1.2212166739510488 1.2999999999999998e-06 1.178387784090909 1.3899999999999998e-06 1.178387784090909 1.4e-06 1.1355588942307693 1.49e-06 1.1355588942307693 1.5e-06 1.0927300043706294 1.59e-06 1.0927300043706294 1.6e-06 1.0499011145104895 1.69e-06 1.0499011145104895 1.6999999999999998e-06 1.0070722246503496 1.7899999999999998e-06 1.0070722246503496 1.8e-06 0.9642433347902097 1.89e-06 0.9642433347902097 1.9e-06 0.92141444493007 1.99e-06 0.92141444493007 2e-06 0.8785855550699301 2.09e-06 0.8785855550699301 2.1e-06 0.8357566652097902 2.1899999999999998e-06 0.8357566652097902 2.2e-06 0.7929277753496503 2.29e-06 0.7929277753496503 2.3e-06 0.7500988854895104 2.39e-06 0.7500988854895104 2.4e-06 0.7072699956293705 2.49e-06 0.7072699956293705 2.4999999999999998e-06 0.6644411057692307 2.5899999999999998e-06 0.6644411057692307 2.5999999999999997e-06 0.6216122159090908 2.6899999999999997e-06 0.6216122159090908 2.7e-06 0.5787833260489511 2.79e-06 0.5787833260489511 2.8e-06 0.5359544361888112 2.89e-06 0.5359544361888112 2.8999999999999998e-06 0.49312554632867134 2.9899999999999997e-06 0.49312554632867134 3e-06 0.45029665646853145 3.09e-06 0.45029665646853145 3.1e-06 0.40746776660839157 3.19e-06 0.40746776660839157 3.2e-06 0.3646388767482517 3.29e-06 0.3646388767482517 3.2999999999999997e-06 0.3218099868881118 3.3899999999999997e-06 0.3218099868881118 3.3999999999999996e-06 0.2789810970279719 3.4899999999999996e-06 0.2789810970279719 3.5e-06 0.23615220716783203 3.59e-06 0.23615220716783203 3.6e-06 0.19332331730769214 3.69e-06 0.19332331730769214 3.6999999999999997e-06 0.15049442744755226 3.7899999999999997e-06 0.15049442744755226 3.8e-06 0.1076655375874126 3.89e-06 0.1076655375874126 3.9e-06 0.06483664772727271 3.99e-06 0.06483664772727271 4e-06 0.8968039772727273 4.09e-06 0.8968039772727273 4.1e-06 0.8963778409090909 4.19e-06 0.8963778409090909 4.2e-06 0.9031960227272727 4.29e-06 0.9031960227272727 4.2999999999999995e-06 0.9036221590909091 4.3899999999999995e-06 0.9036221590909091 4.4e-06 0.8865767045454546 4.49e-06 0.8865767045454546 4.5e-06 0.8861505681818183 4.59e-06 0.8861505681818183 4.6e-06 0.9134232954545455 4.69e-06 0.9134232954545455 4.7e-06 0.9138494318181818 4.79e-06 0.9138494318181818 4.8e-06 0.8456676136363637 4.89e-06 0.8456676136363637 4.9e-06 0.8452414772727272 4.99e-06 0.8452414772727272 4.9999999999999996e-06 0.9543323863636364 5.0899999999999995e-06 0.9543323863636364 5.0999999999999995e-06 0.9547585227272728 5.1899999999999994e-06 0.9547585227272728 5.199999999999999e-06 0.7911221590909091 5.289999999999999e-06 0.7911221590909091 5.3e-06 0.7906960227272728 5.39e-06 0.7906960227272728 5.4e-06 1.0088778409090908 5.49e-06 1.0088778409090908 5.5e-06 1.0093039772727272 5.59e-06 1.0093039772727272 5.6e-06 0.68203125 5.69e-06 0.68203125 5.7e-06 0.6816051136363637 5.79e-06 0.6816051136363637 5.7999999999999995e-06 1.11796875 5.8899999999999995e-06 1.11796875 5.899999999999999e-06 1.1183948863636364 5.989999999999999e-06 1.1183948863636364 6e-06 0.4638494318181818 6.09e-06 0.4638494318181818 6.1e-06 0.46342329545454547 6.19e-06 0.46342329545454547 6.2e-06 1.3361505681818182 6.29e-06 1.3361505681818182 6.3e-06 1.3365767045454546 6.39e-06 1.3365767045454546 6.4e-06 1.3365767045454546]

RSW_p1 (vxp vxp_a1) resistor r=10.0
RSW_p2 (vxp vxp_a2) resistor r=10.0
RSW_n1 (vxn vxn_a1) resistor r=10.0
RSW_n2 (vxn vxn_a2) resistor r=10.0
XSEQ (inp inn vxp vxn outp outn ckc eref b_BP_CP11a b_BP_CP11b b_BP_CN11a b_BP_CN11b b_BP_CP10a b_BP_CP10b b_BP_CN10a b_BP_CN10b b_BP_CP9a b_BP_CP9b b_BP_CN9a b_BP_CN9b b_BP_CP8a b_BP_CP8b b_BP_CN8a b_BP_CN8b b_BP_CP7a b_BP_CP7b b_BP_CN7a b_BP_CN7b b_BP_CP6a b_BP_CP6b b_BP_CN6a b_BP_CN6b b_BP_CP5ac b_BP_CP5bc b_BP_CN5ac b_BP_CN5bc b_BP_CP5a b_BP_CP5b b_BP_CN5a b_BP_CN5b b_BP_CP4 b_BP_CN4 b_BP_CP3 b_BP_CN3 b_BP_CP2 b_BP_CN2 b_BP_CP1 b_BP_CN1) sar_seq

XDUT (b_BP_CP11a b_BP_CP11b b_BP_CP10a b_BP_CP10b b_BP_CP9a b_BP_CP9b b_BP_CP8a b_BP_CP8b b_BP_CP7a b_BP_CP7b b_BP_CP6a b_BP_CP6b b_BP_CP5a b_BP_CP5b b_BP_CP5ac b_BP_CP5bc b_BP_CP4 b_BP_CP3 b_BP_CP2 b_BP_CP1 vxp_a2 vxp_a1 vxp b_BP_CN11a b_BP_CN11b b_BP_CN10a b_BP_CN10b b_BP_CN9a b_BP_CN9b b_BP_CN8a b_BP_CN8b b_BP_CN7a b_BP_CN7b b_BP_CN6a b_BP_CN6b b_BP_CN5a b_BP_CN5b b_BP_CN5ac b_BP_CN5bc b_BP_CN4 b_BP_CN3 b_BP_CN2 b_BP_CN1 vxn_a2 vxn_a1 vxn vdd vss ckc outp outn) sar24_liang_dut CU={{CU}} L_IN={{L_IN}} L_M6={{L_M6}} L_ND={{L_ND}} L_NL={{L_NL}} L_NR={{L_NR}} L_ON={{L_ON}} L_OP={{L_OP}} L_PC={{L_PC}} L_PH={{L_PH}} L_PL={{L_PL}} L_TL={{L_TL}} M_IN={{M_IN}} M_M6={{M_M6}} M_ND={{M_ND}} M_NL={{M_NL}} M_NR={{M_NR}} M_ON={{M_ON}} M_OP={{M_OP}} M_PC={{M_PC}} M_PH={{M_PH}} M_PL={{M_PL}} M_TL={{M_TL}} W_IN={{W_IN}} W_M6={{W_M6}} W_ND={{W_ND}} W_NL={{W_NL}} W_NR={{W_NR}} W_ON={{W_ON}} W_OP={{W_OP}} W_PC={{W_PC}} W_PH={{W_PH}} W_PL={{W_PL}} W_TL={{W_TL}}

opts options temp=27.0 tnom=27 reltol=0.0001 save=selected
save VSUP:p ckc eref inn inp outn outp vdd vxn vxp

tr1 tran stop=6.4e-06 maxstep=2e-10 errpreset=moderate
