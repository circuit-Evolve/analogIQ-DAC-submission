// analogiq 0.1.0 testbench - generated, do not edit
// task telescopic01_scl180_task_001  topology telescopic01_scl180
// recipe amp_step_v1 v1  condition NN_T27_S1p00 (models NN, 27 C, supply 1.8 V)
// request golden_telescopic01_scl180_task_001  candidate 452035997487ea9d
// execution profile search_full
simulator lang=spectre
global 0
include "<CADENCE_SHARED>/FOUNDRY/analog/180nm/models/spectre/gpdk.scs" section=NN
include "dut.scs"

parameters vcm=0.9 cl=1e-12 step=1.8 band=0.018 og=1.0 vc=0.9 vsup=1.8 vneg=0.0
// Sizing variables set in the testbench (external-bias values).
parameters VB1=0.9620403397490732 VB2=1.5115153646113546
// Supplies (charged to the DUT power metrics).
VSUP (vdd 0) vsource dc=vsup
VNEG (vss 0) vsource dc=vneg
// External bias (topology external_bias; reported separately as bias power).
VB_VB1 (b_VB1 0) vsource dc=VB1
VB_VB2 (b_VB2 0) vsource dc=VB2

// Unity-gain buffer: out -> IPRB -> inn (IPRB is the stb loop-break probe).
VIN (inp 0) vsource type=pulse val0=vc-step/2 val1=vc+step/2 delay=2e-07 rise=1e-09 fall=1e-09 width=1.99e-07 period=4e-07
IPRB (out inn) iprobe
CL (out 0) capacitor c=cl

XDUT (vdd vss inn inp out b_VB1 b_VB2) telescopic01_scl180_dut CC=3.376224377637557e-14 IBIAS=9.857592995535434e-06 L_M1=5.223779894190321e-07 L_M11=3.352148295430785e-07 L_M3=2.7418064541936703e-06 L_M5=9.87610368030221e-06 L_M6=2.9515450755990507e-07 L_M7=3.3714792101020585e-07 L_M8=1.8428526857507365e-07 L_M9=7.29953911036602e-07 N_M8=73.0 RZ=58420.3108850206 W_M1=7.12297825116076e-06 W_M11=2.8516521355584906e-06 W_M3=1.60093553168872e-05 W_M5=2.4563245512014827e-05 W_M6=1.0685480745028321e-06 W_M7=7.727404735802776e-05 W_M8=1.3074802423224164e-06 W_M9=2.67776687168162e-05

opts options temp=27.0 tnom=27 reltol=0.0001 save=selected
save VB_VB1:p VB_VB2:p VNEG:p VSUP:p inn inp out vdd vss

tr1 tran stop=6e-07 maxstep=5e-10 errpreset=moderate
simulator lang=spice
.include 'measures.sp'
.end
