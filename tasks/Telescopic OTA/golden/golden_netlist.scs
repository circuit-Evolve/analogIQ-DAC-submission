// Golden sizing netlist (curator 2026-10-28): the benchmark DUT subckt with its parameter defaults set to
// the golden design (golden_design.json), taken from the verified run's job NN_T27_S1p00/amp_dc_v1.
// The DUT subckt and its parameter values are the same in every job of that run (only the testbench changes).
// Instance line of that run: XDUT (vdd vss inn inp out b_VB1 b_VB2) telescopic01_scl180_dut CC=3.376224377637557e-14 IBIAS=9.857592995535434e-06 L_M1=5.223779894190321e-07 L_M11=3.352148295430785e-07 L_M3=2.7418064541936703e-06 L...
// Testbench-level variables (bias sources, operating levels) are in golden_design.json and testbench decks.
// Generated by analogiq from final.scs (sha256 89233ad514b808fa).
// Connectivity and device models are unchanged except for the listed transformations:
//   - symbols used but not declared in the netlist made DUT parameters: IBIAS_DC
//   - ideal elements kept inside the DUT: IB
//   - M2: junction geometry as/ad/ps/pd rewritten in terms of the bound width (area = Lj*W, perimeter = 2*W + c; Lj and c from the netlist)
//   - M1: junction geometry as/ad/ps/pd rewritten in terms of the bound width (area = Lj*W, perimeter = 2*W + c; Lj and c from the netlist)
//   - M12: junction geometry as/ad/ps/pd rewritten in terms of the bound width (area = Lj*W, perimeter = 2*W + c; Lj and c from the netlist)
//   - M11: junction geometry as/ad/ps/pd rewritten in terms of the bound width (area = Lj*W, perimeter = 2*W + c; Lj and c from the netlist)
//   - M7: junction geometry as/ad/ps/pd rewritten in terms of the bound width (area = Lj*W, perimeter = 2*W + c; Lj and c from the netlist)
//   - M6: junction geometry as/ad/ps/pd rewritten in terms of the bound width (area = Lj*W, perimeter = 2*W + c; Lj and c from the netlist)
//   - M5: junction geometry as/ad/ps/pd rewritten in terms of the bound width (area = Lj*W, perimeter = 2*W + c; Lj and c from the netlist)
//   - M4: junction geometry as/ad/ps/pd rewritten in terms of the bound width (area = Lj*W, perimeter = 2*W + c; Lj and c from the netlist)
//   - M3: junction geometry as/ad/ps/pd rewritten in terms of the bound width (area = Lj*W, perimeter = 2*W + c; Lj and c from the netlist)
//   - M9: junction geometry as/ad/ps/pd rewritten in terms of the bound width (area = Lj*W, perimeter = 2*W + c; Lj and c from the netlist)
//   - M10: junction geometry as/ad/ps/pd rewritten in terms of the bound width (area = Lj*W, perimeter = 2*W + c; Lj and c from the netlist)
//   - M8: junction geometry as/ad/ps/pd rewritten in terms of the bound width (area = Lj*W, perimeter = 2*W + c; Lj and c from the netlist)
//   - netlist parameters bound to sizing variables: IBIAS_DC <- IBIAS
//   - widths bound to sizing variables on fold-capable devices are folded symbolically into ceil(W/max) fingers of W/ceil(W/max) (per-device max [1e-05] m): M1, M10, M11, M12, M2, M3, M4, M5, M6, M7, M8, M9
subckt telescopic01_scl180_dut (VDD VSS Vin_m Vin_p Vout VB1 VB2)
parameters W_M1=7.12297825116076e-06 L_M1=5.223779894190321e-07 W_M3=1.60093553168872e-05 L_M3=2.7418064541936703e-06 W_M9=2.67776687168162e-05 L_M9=7.29953911036602e-07 W_M11=2.8516521355584906e-06 L_M11=3.352148295430785e-07 W_M5=2.4563245512014827e-05 L_M5=9.87610368030221e-06 W_M6=1.0685480745028321e-06 L_M6=2.9515450755990507e-07 W_M7=7.727404735802776e-05 L_M7=3.3714792101020585e-07 W_M8=1.3074802423224164e-06 L_M8=1.8428526857507365e-07 N_M8=73.0 CC=3.376224377637557e-14 RZ=58420.3108850206 IBIAS=9.857592995535434e-06 IBIAS_DC=IBIAS
CC (COMP Vout) capacitor c=CC
RZ (STAGE1 COMP) resistor r=RZ
IB (VDD IBIAS) isource type=dc dc=IBIAS_DC
M2 (N_RIGHT Vin_p TAIL VSS) nmos1 w=(W_M1/max(1, W_M1/1e-05)) l=L_M1 m=max(1, W_M1/1e-05) as=(6e-07*((W_M1/max(1, W_M1/1e-05)))) ad=(6e-07*((W_M1/max(1, W_M1/1e-05)))) ps=max(2*((W_M1/max(1, W_M1/1e-05)))+(1.1999999999999987e-06),0) pd=max(2*((W_M1/max(1, W_M1/1e-05)))+(1.1999999999999987e-06),0)
M1 (N_LEFT Vin_m TAIL VSS) nmos1 w=(W_M1/max(1, W_M1/1e-05)) l=L_M1 m=max(1, W_M1/1e-05) as=(6e-07*((W_M1/max(1, W_M1/1e-05)))) ad=(6e-07*((W_M1/max(1, W_M1/1e-05)))) ps=max(2*((W_M1/max(1, W_M1/1e-05)))+(1.1999999999999987e-06),0) pd=max(2*((W_M1/max(1, W_M1/1e-05)))+(1.1999999999999987e-06),0)
M12 (STAGE1 VB2 N_RIGHT VSS) nmos1 w=(W_M11/max(1, W_M11/1e-05)) l=L_M11 m=max(1, W_M11/1e-05) as=(6e-07*((W_M11/max(1, W_M11/1e-05)))) ad=(6e-07*((W_M11/max(1, W_M11/1e-05)))) ps=max(2*((W_M11/max(1, W_M11/1e-05)))+(1.1999999999999987e-06),0) pd=max(2*((W_M11/max(1, W_M11/1e-05)))+(1.1999999999999987e-06),0)
M11 (MIRROR VB2 N_LEFT VSS) nmos1 w=(W_M11/max(1, W_M11/1e-05)) l=L_M11 m=max(1, W_M11/1e-05) as=(6e-07*((W_M11/max(1, W_M11/1e-05)))) ad=(6e-07*((W_M11/max(1, W_M11/1e-05)))) ps=max(2*((W_M11/max(1, W_M11/1e-05)))+(1.1999999999999987e-06),0) pd=max(2*((W_M11/max(1, W_M11/1e-05)))+(1.1999999999999987e-06),0)
M7 (Vout IBIAS VSS VSS) nmos1 w=(W_M7/max(1, W_M7/1e-05)) l=L_M7 m=max(1, W_M7/1e-05) as=(6.000000000000001e-07*((W_M7/max(1, W_M7/1e-05)))) ad=(6.000000000000001e-07*((W_M7/max(1, W_M7/1e-05)))) ps=max(2*((W_M7/max(1, W_M7/1e-05)))+(1.200000000000002e-06),0) pd=max(2*((W_M7/max(1, W_M7/1e-05)))+(1.200000000000002e-06),0)
M6 (IBIAS IBIAS VSS VSS) nmos1 w=(W_M6/max(1, W_M6/1e-05)) l=L_M6 m=max(1, W_M6/1e-05) as=(6.000000000000001e-07*((W_M6/max(1, W_M6/1e-05)))) ad=(6.000000000000001e-07*((W_M6/max(1, W_M6/1e-05)))) ps=max(2*((W_M6/max(1, W_M6/1e-05)))+(1.2e-06),0) pd=max(2*((W_M6/max(1, W_M6/1e-05)))+(1.2e-06),0)
M5 (TAIL IBIAS VSS VSS) nmos1 w=(W_M5/max(1, W_M5/1e-05)) l=L_M5 m=max(1, W_M5/1e-05) as=(6e-07*((W_M5/max(1, W_M5/1e-05)))) ad=(6e-07*((W_M5/max(1, W_M5/1e-05)))) ps=max(2*((W_M5/max(1, W_M5/1e-05)))+(1.1999999999999987e-06),0) pd=max(2*((W_M5/max(1, W_M5/1e-05)))+(1.1999999999999987e-06),0)
M4 (P_RIGHT MIRROR VDD VDD) pmos1 w=(W_M3/max(1, W_M3/1e-05)) l=L_M3 m=max(1, W_M3/1e-05) as=(6.000000000000001e-07*((W_M3/max(1, W_M3/1e-05)))) ad=(6.000000000000001e-07*((W_M3/max(1, W_M3/1e-05)))) ps=max(2*((W_M3/max(1, W_M3/1e-05)))+(1.1999999999999987e-06),0) pd=max(2*((W_M3/max(1, W_M3/1e-05)))+(1.1999999999999987e-06),0)
M3 (P_LEFT MIRROR VDD VDD) pmos1 w=(W_M3/max(1, W_M3/1e-05)) l=L_M3 m=max(1, W_M3/1e-05) as=(6.000000000000001e-07*((W_M3/max(1, W_M3/1e-05)))) ad=(6.000000000000001e-07*((W_M3/max(1, W_M3/1e-05)))) ps=max(2*((W_M3/max(1, W_M3/1e-05)))+(1.1999999999999987e-06),0) pd=max(2*((W_M3/max(1, W_M3/1e-05)))+(1.1999999999999987e-06),0)
M9 (MIRROR VB1 P_LEFT VDD) pmos1 w=(W_M9/max(1, W_M9/1e-05)) l=L_M9 m=max(1, W_M9/1e-05) as=(6.000000000000001e-07*((W_M9/max(1, W_M9/1e-05)))) ad=(6.000000000000001e-07*((W_M9/max(1, W_M9/1e-05)))) ps=max(2*((W_M9/max(1, W_M9/1e-05)))+(1.2000000000000004e-06),0) pd=max(2*((W_M9/max(1, W_M9/1e-05)))+(1.2000000000000004e-06),0)
M10 (STAGE1 VB1 P_RIGHT VDD) pmos1 w=(W_M9/max(1, W_M9/1e-05)) l=L_M9 m=max(1, W_M9/1e-05) as=(6.000000000000001e-07*((W_M9/max(1, W_M9/1e-05)))) ad=(6.000000000000001e-07*((W_M9/max(1, W_M9/1e-05)))) ps=max(2*((W_M9/max(1, W_M9/1e-05)))+(1.2000000000000004e-06),0) pd=max(2*((W_M9/max(1, W_M9/1e-05)))+(1.2000000000000004e-06),0)
M8 (Vout STAGE1 VDD VDD) pmos1 w=(W_M8/max(1, W_M8/1e-05)) l=L_M8 m=N_M8*max(1, W_M8/1e-05) as=(6.000000000000001e-07*((W_M8/max(1, W_M8/1e-05)))) ad=(3.0000000000000004e-07*((W_M8/max(1, W_M8/1e-05)))) ps=max(2*((W_M8/max(1, W_M8/1e-05)))+(1.200000000000002e-06),0) pd=max(2*((W_M8/max(1, W_M8/1e-05)))+(-3.54e-05),0)
ends telescopic01_scl180_dut
