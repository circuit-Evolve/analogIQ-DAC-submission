// analogiq 0.1.0 testbench - generated, do not edit
// task telescopic01_scl180_task_001  topology telescopic01_scl180
// recipe amp_step_v1 v1  condition NN_T27_S1p00 (models NN, 27 C, supply 1.8 V)
// request telescopic01_scl180_task_001__plan  candidate 1ad1a1f9b5e47ce6
// execution profile search_full
simulator lang=spectre
global 0
include "<CADENCE_SHARED>/FOUNDRY/analog/180nm/models/spectre/gpdk.scs" section=NN
include "dut.scs"

parameters vcm=0.9 cl=1e-12 step=1.8 band=0.018 og=1.0 vc=0.9 vsup=1.8 vneg=0.0
// Sizing variables set in the testbench (external-bias values).
parameters VB1={{VB1}} VB2={{VB2}}
// Supplies (charged to the DUT power metrics).
VSUP (vdd 0) vsource dc=vsup
VNEG (vss 0) vsource dc=vneg
// External bias (topology external_bias; reported separately as bias power).
VB_VB1 (b_VB1 0) vsource dc=VB1
VB_VB2 (b_VB2 0) vsource dc=VB2

// Unity-gain buffer: out -> IPRB -> inn (IPRB is the stb loop-break probe).
VIN (inp 0) vsource type=pulse val0=vc-step/2 val1=vc+step/2 delay=2e-07 rise=1e-09 fall=1e-09 width=1.99e-07 period=4e-07
IPRB (out inn) iprobe
CL (out 0) capacitor c=cl

XDUT (vdd vss inn inp out b_VB1 b_VB2) telescopic01_scl180_dut CC={{CC}} IBIAS={{IBIAS}} L_M1={{L_M1}} L_M11={{L_M11}} L_M3={{L_M3}} L_M5={{L_M5}} L_M6={{L_M6}} L_M7={{L_M7}} L_M8={{L_M8}} L_M9={{L_M9}} M_M1={{M_M1}} M_M11={{M_M11}} M_M3={{M_M3}} M_M5={{M_M5}} M_M6={{M_M6}} M_M7={{M_M7}} M_M9={{M_M9}} N_M8={{N_M8}} RZ={{RZ}} W_M1={{W_M1}} W_M11={{W_M11}} W_M3={{W_M3}} W_M5={{W_M5}} W_M6={{W_M6}} W_M7={{W_M7}} W_M8={{W_M8}} W_M9={{W_M9}}

opts options temp=27.0 tnom=27 reltol=0.0001 save=selected
save VB_VB1:p VB_VB2:p VNEG:p VSUP:p inn inp out vdd vss

tr1 tran stop=6e-07 maxstep=5e-10 errpreset=moderate
simulator lang=spice
.include 'measures.sp'
.end
