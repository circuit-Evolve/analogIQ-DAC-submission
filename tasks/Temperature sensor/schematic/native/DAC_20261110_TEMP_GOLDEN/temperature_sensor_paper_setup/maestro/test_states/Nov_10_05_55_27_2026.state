ADE simulation setup
Test Temperature_sweep: DAC_20261110_TEMP_GOLDEN/temperature_sensor_tb/schematic, simulator spectre
  Output Vout_0C_V = value(getData("V_TEMP" ?result "dc-dc") 0)
  Output Vout_27C_V = value(getData("V_TEMP" ?result "dc-dc") 27)
  Output Vout_100C_V = value(getData("V_TEMP" ?result "dc-dc") 100)
  Output Sensitivity_mV_C = (10 * (value(getData("V_TEMP" ?result "dc-dc") 100) - value(getData("V_TEMP" ?result "dc-dc") 0)))
  Output Output_span_mV = (1000 * (ymax(getData("V_TEMP" ?result "dc-dc")) - ymin(getData("V_TEMP" ?result "dc-dc"))))
  Output Endpoint_linearity_percent_FS = ((100 * ymax(abs((getData("V_TEMP" ?result "dc-dc") - (value(getData("V_TEMP" ?result "dc-dc") 0) + (((value(getData("V_TEMP" ?result "dc-dc") 100) - value(getData("V_TEMP" ?result "dc-dc") 0)) * xval(getData("V_TEMP" ?result "dc-dc"))) / 100)))))) / (ymax(getData("V_TEMP" ?result "dc-dc")) - ymin(getData("V_TEMP" ?result "dc-dc"))))
