// Generated by analogiq from dut_benchmark.scs (sha256 e2769bc3c1706f8d).
// Connectivity and device models are unchanged except for the listed transformations:
//   - sensor_bias.M4: mult bound to M_BC; Spectre multiplicity m follows it
//   - sensor_bias.M4: junction geometry ad/as/pd/ps rewritten in terms of the bound width (area = Lj*W, perimeter = 2*W + c; Lj and c from the netlist)
//   - sensor_bias.M3: mult bound to M_BC; Spectre multiplicity m follows it
//   - sensor_bias.M3: junction geometry ad/as/pd/ps rewritten in terms of the bound width (area = Lj*W, perimeter = 2*W + c; Lj and c from the netlist)
//   - sensor_bias.M2: mult bound to M_BP; Spectre multiplicity m follows it
//   - sensor_bias.M2: junction geometry ad/as/pd/ps rewritten in terms of the bound width (area = Lj*W, perimeter = 2*W + c; Lj and c from the netlist)
//   - sensor_bias.M1: mult bound to M_BP; Spectre multiplicity m follows it
//   - sensor_bias.M1: junction geometry ad/as/pd/ps rewritten in terms of the bound width (area = Lj*W, perimeter = 2*W + c; Lj and c from the netlist)
//   - sensor_bias.M6: mult bound to M_BN; Spectre multiplicity m follows it
//   - sensor_bias.M6: junction geometry ad/as/pd/ps rewritten in terms of the bound width (area = Lj*W, perimeter = 2*W + c; Lj and c from the netlist)
//   - sensor_bias.M5: mult bound to M_BN; Spectre multiplicity m follows it
//   - sensor_bias.M5: junction geometry ad/as/pd/ps rewritten in terms of the bound width (area = Lj*W, perimeter = 2*W + c; Lj and c from the netlist)
//   - sensor_ptat.M7: mult bound to M_P7; Spectre multiplicity m follows it
//   - sensor_ptat.M7: junction geometry ad/as/pd/ps rewritten in terms of the bound width (area = Lj*W, perimeter = 2*W + c; Lj and c from the netlist)
//   - sensor_ptat.M9: mult bound to M_N9; Spectre multiplicity m follows it
//   - sensor_ptat.M9: junction geometry ad/as/pd/ps rewritten in terms of the bound width (area = Lj*W, perimeter = 2*W + c; Lj and c from the netlist)
//   - sensor_ptat.M8: mult bound to M_N8; Spectre multiplicity m follows it
//   - sensor_ptat.M8: junction geometry ad/as/pd/ps rewritten in terms of the bound width (area = Lj*W, perimeter = 2*W + c; Lj and c from the netlist)
//   - sensor_amplifier.M11: mult bound to M_LD; Spectre multiplicity m follows it
//   - sensor_amplifier.M11: junction geometry ad/as/pd/ps rewritten in terms of the bound width (area = Lj*W, perimeter = 2*W + c; Lj and c from the netlist)
//   - sensor_amplifier.M10: mult bound to M_LD; Spectre multiplicity m follows it
//   - sensor_amplifier.M10: junction geometry ad/as/pd/ps rewritten in terms of the bound width (area = Lj*W, perimeter = 2*W + c; Lj and c from the netlist)
//   - sensor_amplifier.M14: mult bound to M_TL; Spectre multiplicity m follows it
//   - sensor_amplifier.M14: junction geometry ad/as/pd/ps rewritten in terms of the bound width (area = Lj*W, perimeter = 2*W + c; Lj and c from the netlist)
//   - sensor_amplifier.M13: mult bound to M_I13; Spectre multiplicity m follows it
//   - sensor_amplifier.M13: junction geometry ad/as/pd/ps rewritten in terms of the bound width (area = Lj*W, perimeter = 2*W + c; Lj and c from the netlist)
//   - sensor_amplifier.M12: mult bound to M_I12; Spectre multiplicity m follows it
//   - sensor_amplifier.M12: junction geometry ad/as/pd/ps rewritten in terms of the bound width (area = Lj*W, perimeter = 2*W + c; Lj and c from the netlist)
//   - sizing variables bound inside local subckts are subckt parameters passed from the DUT instance(s): sensor_bias: ['L_BC', 'L_BN', 'L_BP', 'M_BC', 'M_BN', 'M_BP', 'W_BC', 'W_BN', 'W_BP'], sensor_ptat: ['L_N8', 'L_N9', 'L_P7', 'M_N8', 'M_N9', 'M_P7', 'W_N8', 'W_N9', 'W_P7'], sensor_amplifier: ['L_I12', 'L_I13', 'L_LD', 'L_TL', 'M_I12', 'M_I13', 'M_LD', 'M_TL', 'W_I12', 'W_I13', 'W_LD', 'W_TL']
subckt sensor_bias (NBIAS VDD VSS)
  parameters L_BC=1e-06 L_BN=1e-06 L_BP=1e-06 M_BC=1.0 M_BN=1.0 M_BP=1.0 W_BC=1e-06 W_BN=1e-06 W_BP=1e-06
  M4 (NDIO NBIAS PCAS VDD) sky130_fd_pr__pfet_01v8 w=(W_BC/1e-06) l=(L_BC/1e-06) nf=1 mult=M_BC ad=(0.29*((W_BC/1e-06))) as=(0.29*((W_BC/1e-06))) pd=max(2*((W_BC/1e-06))+(0.5799999999999998),0) ps=max(2*((W_BC/1e-06))+(0.5799999999999998),0) sa=0 sb=0 sd=0 m=M_BC
  M3 (NBIAS NBIAS PBIAS VDD) sky130_fd_pr__pfet_01v8 w=(W_BC/1e-06) l=(L_BC/1e-06) nf=1 mult=M_BC ad=(0.29*((W_BC/1e-06))) as=(0.29*((W_BC/1e-06))) pd=max(2*((W_BC/1e-06))+(0.5799999999999998),0) ps=max(2*((W_BC/1e-06))+(0.5799999999999998),0) sa=0 sb=0 sd=0 m=M_BC
  M2 (PCAS PBIAS VDD VDD) sky130_fd_pr__pfet_01v8 w=(W_BP/1e-06) l=(L_BP/1e-06) nf=1 mult=M_BP ad=(0.29*((W_BP/1e-06))) as=(0.29*((W_BP/1e-06))) pd=max(2*((W_BP/1e-06))+(0.5799999999999998),0) ps=max(2*((W_BP/1e-06))+(0.5799999999999998),0) sa=0 sb=0 sd=0 m=M_BP
  M1 (PBIAS PBIAS VDD VDD) sky130_fd_pr__pfet_01v8 w=(W_BP/1e-06) l=(L_BP/1e-06) nf=1 mult=M_BP ad=(0.29*((W_BP/1e-06))) as=(0.29*((W_BP/1e-06))) pd=max(2*((W_BP/1e-06))+(0.5799999999999998),0) ps=max(2*((W_BP/1e-06))+(0.5799999999999998),0) sa=0 sb=0 sd=0 m=M_BP
  M6 (NDIO NDIO VSS VSS) sky130_fd_pr__nfet_01v8 w=(W_BN/1e-06) l=(L_BN/1e-06) nf=1 mult=M_BN ad=(0.29*((W_BN/1e-06))) as=(0.29*((W_BN/1e-06))) pd=max(2*((W_BN/1e-06))+(0.58),0) ps=max(2*((W_BN/1e-06))+(0.58),0) sa=0 sb=0 sd=0 m=M_BN
  M5 (NBIAS NBIAS VSS VSS) sky130_fd_pr__nfet_01v8 w=(W_BN/1e-06) l=(L_BN/1e-06) nf=1 mult=M_BN ad=(0.29*((W_BN/1e-06))) as=(0.29*((W_BN/1e-06))) pd=max(2*((W_BN/1e-06))+(0.58),0) ps=max(2*((W_BN/1e-06))+(0.58),0) sa=0 sb=0 sd=0 m=M_BN
ends sensor_bias
subckt sensor_ptat (NBIAS VDD VN VP VSS)
  parameters L_N8=1e-06 L_N9=1e-06 L_P7=1e-06 M_N8=1.0 M_N9=1.0 M_P7=1.0 W_N8=1e-06 W_N9=1e-06 W_P7=1e-06
  M7 (NMIR NBIAS VDD VDD) sky130_fd_pr__pfet_01v8 w=(W_P7/1e-06) l=(L_P7/1e-06) nf=1 mult=M_P7 ad=(0.29*((W_P7/1e-06))) as=(0.29*((W_P7/1e-06))) pd=max(2*((W_P7/1e-06))+(0.5800000000000001),0) ps=max(2*((W_P7/1e-06))+(0.5800000000000001),0) sa=0 sb=0 sd=0 m=M_P7
  M9 (VDD NMIR VP VSS) sky130_fd_pr__nfet_01v8 w=(W_N9/1e-06) l=(L_N9/1e-06) nf=1 mult=M_N9 ad=(0.29*((W_N9/1e-06))) as=(0.29*((W_N9/1e-06))) pd=max(2*((W_N9/1e-06))+(0.5800000000000001),0) ps=max(2*((W_N9/1e-06))+(0.5800000000000001),0) sa=0 sb=0 sd=0 m=M_N9
  M8 (NMIR NMIR VN VSS) sky130_fd_pr__nfet_01v8 w=(W_N8/1e-06) l=(L_N8/1e-06) nf=1 mult=M_N8 ad=(0.29*((W_N8/1e-06))) as=(0.29*((W_N8/1e-06))) pd=max(2*((W_N8/1e-06))+(0.5800000000000001),0) ps=max(2*((W_N8/1e-06))+(0.5800000000000001),0) sa=0 sb=0 sd=0 m=M_N8
  Q2 (VSS VSS VP) sky130_fd_pr__pnp_05v5_W3p40L3p40 mult=1
  Q1 (VSS VSS VN) sky130_fd_pr__pnp_05v5_W3p40L3p40 mult=1
ends sensor_ptat
subckt sensor_amplifier (NBIAS VDD VN VP VSS V_TEMP)
  parameters L_I12=1e-06 L_I13=1e-06 L_LD=1e-06 L_TL=1e-06 M_I12=1.0 M_I13=1.0 M_LD=1.0 M_TL=1.0 W_I12=1e-06 W_I13=1e-06 W_LD=1e-06 W_TL=1e-06
  M11 (V_TEMP NLOAD VDD VDD) sky130_fd_pr__pfet_01v8 w=(W_LD/1e-06) l=(L_LD/1e-06) nf=1 mult=M_LD ad=(0.29*((W_LD/1e-06))) as=(0.29*((W_LD/1e-06))) pd=max(2*((W_LD/1e-06))+(0.5800000000000001),0) ps=max(2*((W_LD/1e-06))+(0.5800000000000001),0) sa=0 sb=0 sd=0 m=M_LD
  M10 (NLOAD NLOAD VDD VDD) sky130_fd_pr__pfet_01v8 w=(W_LD/1e-06) l=(L_LD/1e-06) nf=1 mult=M_LD ad=(0.29*((W_LD/1e-06))) as=(0.29*((W_LD/1e-06))) pd=max(2*((W_LD/1e-06))+(0.5800000000000001),0) ps=max(2*((W_LD/1e-06))+(0.5800000000000001),0) sa=0 sb=0 sd=0 m=M_LD
  M14 (TAIL NBIAS VSS VSS) sky130_fd_pr__nfet_01v8 w=(W_TL/1e-06) l=(L_TL/1e-06) nf=1 mult=M_TL ad=(0.29*((W_TL/1e-06))) as=(0.29*((W_TL/1e-06))) pd=max(2*((W_TL/1e-06))+(0.5799999999999983),0) ps=max(2*((W_TL/1e-06))+(0.5799999999999983),0) sa=0 sb=0 sd=0 m=M_TL
  M13 (V_TEMP VP TAIL VSS) sky130_fd_pr__nfet_01v8 w=(W_I13/1e-06) l=(L_I13/1e-06) nf=1 mult=M_I13 ad=(0.29*((W_I13/1e-06))) as=(0.29*((W_I13/1e-06))) pd=max(2*((W_I13/1e-06))+(0.58),0) ps=max(2*((W_I13/1e-06))+(0.58),0) sa=0 sb=0 sd=0 m=M_I13
  M12 (NLOAD VN TAIL VSS) sky130_fd_pr__nfet_01v8 w=(W_I12/1e-06) l=(L_I12/1e-06) nf=1 mult=M_I12 ad=(0.29*((W_I12/1e-06))) as=(0.29*((W_I12/1e-06))) pd=max(2*((W_I12/1e-06))+(0.58),0) ps=max(2*((W_I12/1e-06))+(0.58),0) sa=0 sb=0 sd=0 m=M_I12
ends sensor_amplifier
subckt ts1111_sensor_dut (VDD VSS V_TEMP)
parameters W_BP=1e-06 L_BP=1e-06 M_BP=1.0 W_BC=1e-06 L_BC=1e-06 M_BC=1.0 W_BN=1e-06 L_BN=1e-06 M_BN=1.0 W_P7=1e-06 L_P7=1e-06 M_P7=1.0 W_N8=1e-06 L_N8=1e-06 M_N8=1.0 W_N9=1e-06 L_N9=1e-06 M_N9=1.0 W_LD=1e-06 L_LD=1e-06 M_LD=1.0 W_I12=1e-06 L_I12=1e-06 M_I12=1.0 W_I13=1e-06 L_I13=1e-06 M_I13=1.0 W_TL=1e-06 L_TL=1e-06 M_TL=1.0
BIAS (NBIAS VDD VSS) sensor_bias L_BC=L_BC L_BN=L_BN L_BP=L_BP M_BC=M_BC M_BN=M_BN M_BP=M_BP W_BC=W_BC W_BN=W_BN W_BP=W_BP
PTAT (NBIAS VDD VN VP VSS) sensor_ptat L_N8=L_N8 L_N9=L_N9 L_P7=L_P7 M_N8=M_N8 M_N9=M_N9 M_P7=M_P7 W_N8=W_N8 W_N9=W_N9 W_P7=W_P7
AMP (NBIAS VDD VN VP VSS V_TEMP) sensor_amplifier L_I12=L_I12 L_I13=L_I13 L_LD=L_LD L_TL=L_TL M_I12=M_I12 M_I13=M_I13 M_LD=M_LD M_TL=M_TL W_I12=W_I12 W_I13=W_I13 W_LD=W_LD W_TL=W_TL
ends ts1111_sensor_dut
