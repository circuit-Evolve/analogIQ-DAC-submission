// Golden sizing netlist (curator 2026-10-28): the benchmark DUT subckt with its parameter defaults set to
// the golden design (golden_design.json), taken from the verified run's job NN_T27_S1p00_CL0/amp30_step_v1.
// The DUT subckt and its parameter values are the same in every job of that run (only the testbench changes).
// Instance line of that run: XDUT (inp inn out vdd vss b_VB1 b_VB2 b_VB3) ota3s24_dut CC1=8.174308274866054e-14 CC2=5.143722960283856e-13 CD=1.6491454828373294e-13 L_M0=7.667849810308635e-06 L_M1=4.912088701060295e-06 L_M2=5.2241...
// Testbench-level variables (bias sources, operating levels) are in golden_design.json and testbench decks.
// Generated by analogiq from dut_benchmark.scs (sha256 f8bd19a9e55b4a64).
// Connectivity and device models are unchanged except for the listed transformations:
//   - M0: junction geometry ad/as/pd/ps rewritten in terms of the bound width (area = Lj*W, perimeter = 2*W + c; Lj and c from the netlist)
//   - M1a: junction geometry ad/as/pd/ps rewritten in terms of the bound width (area = Lj*W, perimeter = 2*W + c; Lj and c from the netlist)
//   - M1b: junction geometry ad/as/pd/ps rewritten in terms of the bound width (area = Lj*W, perimeter = 2*W + c; Lj and c from the netlist)
//   - M2a: junction geometry ad/as/pd/ps rewritten in terms of the bound width (area = Lj*W, perimeter = 2*W + c; Lj and c from the netlist)
//   - M2b: junction geometry ad/as/pd/ps rewritten in terms of the bound width (area = Lj*W, perimeter = 2*W + c; Lj and c from the netlist)
//   - M3a: junction geometry ad/as/pd/ps rewritten in terms of the bound width (area = Lj*W, perimeter = 2*W + c; Lj and c from the netlist)
//   - M3b: junction geometry ad/as/pd/ps rewritten in terms of the bound width (area = Lj*W, perimeter = 2*W + c; Lj and c from the netlist)
//   - M4a: junction geometry ad/as/pd/ps rewritten in terms of the bound width (area = Lj*W, perimeter = 2*W + c; Lj and c from the netlist)
//   - M4b: junction geometry ad/as/pd/ps rewritten in terms of the bound width (area = Lj*W, perimeter = 2*W + c; Lj and c from the netlist)
//   - M5: junction geometry ad/as/pd/ps rewritten in terms of the bound width (area = Lj*W, perimeter = 2*W + c; Lj and c from the netlist)
//   - M6a: junction geometry ad/as/pd/ps rewritten in terms of the bound width (area = Lj*W, perimeter = 2*W + c; Lj and c from the netlist)
//   - M6b: junction geometry ad/as/pd/ps rewritten in terms of the bound width (area = Lj*W, perimeter = 2*W + c; Lj and c from the netlist)
//   - M7: junction geometry ad/as/pd/ps rewritten in terms of the bound width (area = Lj*W, perimeter = 2*W + c; Lj and c from the netlist)
//   - M8: junction geometry ad/as/pd/ps rewritten in terms of the bound width (area = Lj*W, perimeter = 2*W + c; Lj and c from the netlist)
//   - M9: junction geometry ad/as/pd/ps rewritten in terms of the bound width (area = Lj*W, perimeter = 2*W + c; Lj and c from the netlist)
//   - widths bound to sizing variables on fold-capable devices are folded symbolically into ceil(W/max) fingers of W/ceil(W/max) (per-device max [1e-05] m): M0, M1a, M1b, M2a, M2b, M3a, M3b, M4a, M4b, M5, M6a, M6b, M7, M8, M9
subckt ota3s24_dut (VIP VIN VO VDD VSS VB1 VB2 VB3)
parameters W_M0=8.098029815012366e-06 L_M0=7.667849810308635e-06 W_M1=1.7229516936130143e-05 L_M1=4.912088701060295e-06 W_M2=1.3128449910518226e-05 L_M2=5.22412495444643e-06 W_M3=8.380017783938899e-06 L_M3=3.1104574530227926e-06 W_M4=2.0066084087538857e-05 L_M4=1.2293584650483118e-06 W_M5=2.5919623511007866e-06 L_M5=1.968240141992717e-07 W_M7=1.4376240939872487e-05 L_M7=1.038032655793574e-05 W_M8=1.858061284684332e-05 L_M8=1.8000000000000013e-07 W_M9=5.935517818924883e-06 L_M9=1.8000000000000013e-07 W_M6A=2.0837504240408397e-06 W_M6B=4.281114771658617e-06 L_M6=3.1157676023169295e-06 RD=54413.34118674204 CD=1.6491454828373294e-13 CC1=8.174308274866054e-14 CC2=5.143722960283856e-13
M0 (TAIL VB1 VDD VDD) pmos1 w=(W_M0/max(1, W_M0/1e-05)) l=L_M0 m=max(1, W_M0/1e-05) ad=(6.000000000000001e-07*((W_M0/max(1, W_M0/1e-05)))) as=(6.000000000000001e-07*((W_M0/max(1, W_M0/1e-05)))) pd=max(2*((W_M0/max(1, W_M0/1e-05)))+(1.200000000000002e-06),0) ps=max(2*((W_M0/max(1, W_M0/1e-05)))+(1.200000000000002e-06),0)
M1a (FOLD_A VIP TAIL TAIL) pmos1 w=(W_M1/max(1, W_M1/1e-05)) l=L_M1 m=max(1, W_M1/1e-05) ad=(6.000000000000001e-07*((W_M1/max(1, W_M1/1e-05)))) as=(6.000000000000001e-07*((W_M1/max(1, W_M1/1e-05)))) pd=max(2*((W_M1/max(1, W_M1/1e-05)))+(1.1999999999999987e-06),0) ps=max(2*((W_M1/max(1, W_M1/1e-05)))+(1.1999999999999987e-06),0)
M1b (FOLD_B VIN TAIL TAIL) pmos1 w=(W_M1/max(1, W_M1/1e-05)) l=L_M1 m=max(1, W_M1/1e-05) ad=(6.000000000000001e-07*((W_M1/max(1, W_M1/1e-05)))) as=(6.000000000000001e-07*((W_M1/max(1, W_M1/1e-05)))) pd=max(2*((W_M1/max(1, W_M1/1e-05)))+(1.1999999999999987e-06),0) ps=max(2*((W_M1/max(1, W_M1/1e-05)))+(1.1999999999999987e-06),0)
M2a (FOLD_A VB2 VSS VSS) nmos1 w=(W_M2/max(1, W_M2/1e-05)) l=L_M2 m=max(1, W_M2/1e-05) ad=(6e-07*((W_M2/max(1, W_M2/1e-05)))) as=(6e-07*((W_M2/max(1, W_M2/1e-05)))) pd=max(2*((W_M2/max(1, W_M2/1e-05)))+(1.1999999999999987e-06),0) ps=max(2*((W_M2/max(1, W_M2/1e-05)))+(1.1999999999999987e-06),0)
M2b (FOLD_B VB2 VSS VSS) nmos1 w=(W_M2/max(1, W_M2/1e-05)) l=L_M2 m=max(1, W_M2/1e-05) ad=(6e-07*((W_M2/max(1, W_M2/1e-05)))) as=(6e-07*((W_M2/max(1, W_M2/1e-05)))) pd=max(2*((W_M2/max(1, W_M2/1e-05)))+(1.1999999999999987e-06),0) ps=max(2*((W_M2/max(1, W_M2/1e-05)))+(1.1999999999999987e-06),0)
M3a (VO1 VB3 FOLD_A VSS) nmos1 w=(W_M3/max(1, W_M3/1e-05)) l=L_M3 m=max(1, W_M3/1e-05) ad=(6.000000000000001e-07*((W_M3/max(1, W_M3/1e-05)))) as=(6.000000000000001e-07*((W_M3/max(1, W_M3/1e-05)))) pd=max(2*((W_M3/max(1, W_M3/1e-05)))+(1.200000000000002e-06),0) ps=max(2*((W_M3/max(1, W_M3/1e-05)))+(1.200000000000002e-06),0)
M3b (MIRROR_P VB3 FOLD_B VSS) nmos1 w=(W_M3/max(1, W_M3/1e-05)) l=L_M3 m=max(1, W_M3/1e-05) ad=(6.000000000000001e-07*((W_M3/max(1, W_M3/1e-05)))) as=(6.000000000000001e-07*((W_M3/max(1, W_M3/1e-05)))) pd=max(2*((W_M3/max(1, W_M3/1e-05)))+(1.200000000000002e-06),0) ps=max(2*((W_M3/max(1, W_M3/1e-05)))+(1.200000000000002e-06),0)
M4a (VO1 MIRROR_P VDD VDD) pmos1 w=(W_M4/max(1, W_M4/1e-05)) l=L_M4 m=max(1, W_M4/1e-05) ad=(6.000000000000001e-07*((W_M4/max(1, W_M4/1e-05)))) as=(6.000000000000001e-07*((W_M4/max(1, W_M4/1e-05)))) pd=max(2*((W_M4/max(1, W_M4/1e-05)))+(1.1999999999999987e-06),0) ps=max(2*((W_M4/max(1, W_M4/1e-05)))+(1.1999999999999987e-06),0)
M4b (MIRROR_P MIRROR_P VDD VDD) pmos1 w=(W_M4/max(1, W_M4/1e-05)) l=L_M4 m=max(1, W_M4/1e-05) ad=(6.000000000000001e-07*((W_M4/max(1, W_M4/1e-05)))) as=(6.000000000000001e-07*((W_M4/max(1, W_M4/1e-05)))) pd=max(2*((W_M4/max(1, W_M4/1e-05)))+(1.1999999999999987e-06),0) ps=max(2*((W_M4/max(1, W_M4/1e-05)))+(1.1999999999999987e-06),0)
M5 (MIRROR_N VO1 VDD VDD) pmos1 w=(W_M5/max(1, W_M5/1e-05)) l=L_M5 m=max(1, W_M5/1e-05) ad=(6.000000000000001e-07*((W_M5/max(1, W_M5/1e-05)))) as=(6.000000000000001e-07*((W_M5/max(1, W_M5/1e-05)))) pd=max(2*((W_M5/max(1, W_M5/1e-05)))+(1.1999999999999995e-06),0) ps=max(2*((W_M5/max(1, W_M5/1e-05)))+(1.1999999999999995e-06),0)
M6a (VO2 MIRROR_N VSS VSS) nmos1 w=(W_M6A/max(1, W_M6A/1e-05)) l=L_M6 m=max(1, W_M6A/1e-05) ad=(6.000000000000001e-07*((W_M6A/max(1, W_M6A/1e-05)))) as=(6.000000000000001e-07*((W_M6A/max(1, W_M6A/1e-05)))) pd=max(2*((W_M6A/max(1, W_M6A/1e-05)))+(1.2000000000000004e-06),0) ps=max(2*((W_M6A/max(1, W_M6A/1e-05)))+(1.2000000000000004e-06),0)
M6b (MIRROR_N MIRROR_N VSS VSS) nmos1 w=(W_M6B/max(1, W_M6B/1e-05)) l=L_M6 m=max(1, W_M6B/1e-05) ad=(6e-07*((W_M6B/max(1, W_M6B/1e-05)))) as=(6e-07*((W_M6B/max(1, W_M6B/1e-05)))) pd=max(2*((W_M6B/max(1, W_M6B/1e-05)))+(1.2000000000000004e-06),0) ps=max(2*((W_M6B/max(1, W_M6B/1e-05)))+(1.2000000000000004e-06),0)
M7 (VO2 VB1 VDD VDD) pmos1 w=(W_M7/max(1, W_M7/1e-05)) l=L_M7 m=max(1, W_M7/1e-05) ad=(6.000000000000001e-07*((W_M7/max(1, W_M7/1e-05)))) as=(6.000000000000001e-07*((W_M7/max(1, W_M7/1e-05)))) pd=max(2*((W_M7/max(1, W_M7/1e-05)))+(1.200000000000002e-06),0) ps=max(2*((W_M7/max(1, W_M7/1e-05)))+(1.200000000000002e-06),0)
M8 (VO VO2 VSS VSS) nmos1 w=(W_M8/max(1, W_M8/1e-05)) l=L_M8 m=max(1, W_M8/1e-05) ad=(6.000000000000001e-07*((W_M8/max(1, W_M8/1e-05)))) as=(6.000000000000001e-07*((W_M8/max(1, W_M8/1e-05)))) pd=max(2*((W_M8/max(1, W_M8/1e-05)))+(1.1999999999999953e-06),0) ps=max(2*((W_M8/max(1, W_M8/1e-05)))+(1.1999999999999953e-06),0)
M9 (VO VO1 VDD VDD) pmos1 w=(W_M9/max(1, W_M9/1e-05)) l=L_M9 m=max(1, W_M9/1e-05) ad=(6e-07*((W_M9/max(1, W_M9/1e-05)))) as=(6e-07*((W_M9/max(1, W_M9/1e-05)))) pd=max(2*((W_M9/max(1, W_M9/1e-05)))+(1.200000000000002e-06),0) ps=max(2*((W_M9/max(1, W_M9/1e-05)))+(1.200000000000002e-06),0)
RD (VO1 RD_CD) resistor r=RD m=1
CD (RD_CD VSS) capacitor c=CD m=1
CC1 (FOLD_B VO2) capacitor c=CC1 m=1
CC2 (FOLD_A VO) capacitor c=CC2 m=1
ends ota3s24_dut
