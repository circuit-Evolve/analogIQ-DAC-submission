// analogiq 0.1.0 testbench - generated, do not edit
// task ota3s24_task_001  topology ota3s24
// recipe amp_ol_v1 v3  condition NN_T27_S1p00_CL100n (models NN, 27 C, supply 1.8 V)
// request ota3s24_task_001__plan  candidate 25f7ea5cdf3edbba
// execution profile search_full
simulator lang=spectre
global 0
include "<CADENCE_SHARED>/FOUNDRY/analog/180nm/models/spectre/gpdk.scs" section=NN
include "dut.scs"

parameters vcm=0.45 cl=1e-07 a_inp=1.0 a_inn=0.0 a_vdd=0.0 a_vss=0.0 vsup=1.8 vneg=0.0
// Sizing variables set in the testbench (external-bias values).
parameters VB1={{VB1}} VB2={{VB2}} VB3={{VB3}}
// Supplies (charged to the DUT power metrics).
VSUP (vdd 0) vsource dc=vsup mag=a_vdd
VNEG (vss 0) vsource dc=vneg mag=a_vss
// External bias (topology external_bias; reported separately as bias power).
VB_VB1 (b_VB1 0) vsource dc=VB1
VB_VB2 (b_VB2 0) vsource dc=VB2
VB_VB3 (b_VB3 0) vsource dc=VB3

// Open loop: DC loop closed by LF (out -> inn), AC injected into inn through CF.
VIN (inp 0) vsource dc=vcm mag=a_inp
VACN (acn 0) vsource dc=0 mag=a_inn
CF (acn inn) capacitor c=1e+18
LF (out inn) inductor l=1e+18
EINV (outinv 0 out 0) vcvs gain=-1
CL (out 0) capacitor c=cl

XDUT (inp inn out vdd vss b_VB1 b_VB2 b_VB3) ota3s24_dut CC1={{CC1}} CC2={{CC2}} CD={{CD}} L_M0={{L_M0}} L_M1={{L_M1}} L_M2={{L_M2}} L_M3={{L_M3}} L_M4={{L_M4}} L_M5={{L_M5}} L_M6={{L_M6}} L_M7={{L_M7}} L_M8={{L_M8}} L_M9={{L_M9}} M_M0={{M_M0}} M_M1={{M_M1}} M_M2={{M_M2}} M_M3={{M_M3}} M_M4={{M_M4}} M_M5={{M_M5}} M_M6A={{M_M6A}} M_M6B={{M_M6B}} M_M7={{M_M7}} M_M8={{M_M8}} M_M9={{M_M9}} RD={{RD}} W_M0={{W_M0}} W_M1={{W_M1}} W_M2={{W_M2}} W_M3={{W_M3}} W_M4={{W_M4}} W_M5={{W_M5}} W_M6A={{W_M6A}} W_M6B={{W_M6B}} W_M7={{W_M7}} W_M8={{W_M8}} W_M9={{W_M9}}

opts options temp=27.0 tnom=27 reltol=0.0001 save=selected
save VB_VB1:p VB_VB2:p VB_VB3:p VNEG:p VSUP:p inn inp out vdd vss

ac1 ac start=1.0 stop=1000000000.0 dec=20
simulator lang=spice
.include 'measures.sp'
.alter
* point p001
.param a_inp=1 a_inn=1 a_vdd=0 a_vss=0
.alter
* point p002
.param a_inp=0 a_inn=0 a_vdd=1 a_vss=0
.alter
* point p003
.param a_inp=0 a_inn=0 a_vdd=0 a_vss=1
.end
