// analogiq 0.1.0 testbench - generated, do not edit
// task ota3s24_task_001  topology ota3s24
// recipe amp30_step_v1 v1  condition NN_T27_S1p00_CL500p (models NN, 27 C, supply 1.8 V)
// request ota3s24_task_001__plan  candidate 25f7ea5cdf3edbba
// execution profile search_full
simulator lang=spectre
global 0
include "<CADENCE_SHARED>/FOUNDRY/analog/180nm/models/spectre/gpdk.scs" section=NN
include "dut.scs"

parameters vcm=0.6 cl=5e-10 step=0.4 band=0.004 og=1.0 vc=0.6 vsup=1.8 vneg=0.0
// Sizing variables set in the testbench (external-bias values).
parameters VB1={{VB1}} VB2={{VB2}} VB3={{VB3}}
// Supplies (charged to the DUT power metrics).
VSUP (vdd 0) vsource dc=vsup
VNEG (vss 0) vsource dc=vneg
// External bias (topology external_bias; reported separately as bias power).
VB_VB1 (b_VB1 0) vsource dc=VB1
VB_VB2 (b_VB2 0) vsource dc=VB2
VB_VB3 (b_VB3 0) vsource dc=VB3

// Unity-gain buffer: out -> IPRB -> inn (IPRB is the stb loop-break probe).
VIN (inp 0) vsource type=pulse val0=vc-step/2 val1=vc+step/2 delay=2e-05 rise=1e-09 fall=1e-09 width=1.9999000000000003e-05 period=4e-05
IPRB (out inn) iprobe
CL (out 0) capacitor c=cl

XDUT (inp inn out vdd vss b_VB1 b_VB2 b_VB3) ota3s24_dut CC1={{CC1}} CC2={{CC2}} CD={{CD}} L_M0={{L_M0}} L_M1={{L_M1}} L_M2={{L_M2}} L_M3={{L_M3}} L_M4={{L_M4}} L_M5={{L_M5}} L_M6={{L_M6}} L_M7={{L_M7}} L_M8={{L_M8}} L_M9={{L_M9}} M_M0={{M_M0}} M_M1={{M_M1}} M_M2={{M_M2}} M_M3={{M_M3}} M_M4={{M_M4}} M_M5={{M_M5}} M_M6A={{M_M6A}} M_M6B={{M_M6B}} M_M7={{M_M7}} M_M8={{M_M8}} M_M9={{M_M9}} RD={{RD}} W_M0={{W_M0}} W_M1={{W_M1}} W_M2={{W_M2}} W_M3={{W_M3}} W_M4={{W_M4}} W_M5={{W_M5}} W_M6A={{W_M6A}} W_M6B={{W_M6B}} W_M7={{W_M7}} W_M8={{W_M8}} W_M9={{W_M9}}

opts options temp=27.0 tnom=27 reltol=0.0001 save=selected
save VB_VB1:p VB_VB2:p VB_VB3:p VNEG:p VSUP:p inn inp out vdd vss

tr1 tran stop=6.000000000000001e-05 maxstep=2e-08 errpreset=moderate
simulator lang=spice
.include 'measures.sp'
.end
