// Verified TIA recovery sizing, 2026-11-12; nominal G8 qualification.
// Generated by analogiq from final.scs (sha256 4f05ac3c804615ab).
// Connectivity and device models are unchanged except for the listed transformations:
//   - symbols used but not declared in the netlist made DUT parameters: C_FB, C_NCG, I_PHOTO, V_BIAS
//   - ideal elements kept inside the DUT: IBIAS1, IBIAS2, IPHOTO, VBIAS_SOURCE
//   - M1: junction geometry as/ad/ps/pd rewritten in terms of the bound width (area = Lj*W, perimeter = 2*W + c; Lj and c from the netlist)
//   - M2: junction geometry as/ad/ps/pd rewritten in terms of the bound width (area = Lj*W, perimeter = 2*W + c; Lj and c from the netlist)
//   - M3: junction geometry as/ad/ps/pd rewritten in terms of the bound width (area = Lj*W, perimeter = 2*W + c; Lj and c from the netlist)
//   - M4: junction geometry as/ad/ps/pd rewritten in terms of the bound width (area = Lj*W, perimeter = 2*W + c; Lj and c from the netlist)
//   - M5: junction geometry as/ad/ps/pd rewritten in terms of the bound width (area = Lj*W, perimeter = 2*W + c; Lj and c from the netlist)
//   - M6: junction geometry as/ad/ps/pd rewritten in terms of the bound width (area = Lj*W, perimeter = 2*W + c; Lj and c from the netlist)
//   - netlist parameters bound to sizing variables: C_FB <- C_FB, C_NCG <- C_NCG, V_BIAS <- V_BIAS
//   - widths bound to sizing variables on fold-capable devices are folded symbolically into ceil(W/max) fingers of W/ceil(W/max) (per-device max [1e-05] m): M1, M2, M3, M4, M5, M6
subckt tia02_dut (VDD GND IIN VOUT)
parameters W_M1=3.657458195642558e-06 L_M1=1.8000000000000013e-07 W_M23=1.4016309970338957e-06 L_M23=1.9069871673236854e-07 W_M45=4e-07 L_M45=1.01327771772505e-06 W_M6=4e-07 L_M6=3.2755420534706423e-07 R_F=10.000000000000002 C_FB=1.6704328827205776e-13 C_NCG=1.8654253068635632e-12 I_BIAS1=1.2452370327579653e-05 I_BIAS2=0.00036323944511449757 V_BIAS=1.2102881986767737 N_M1=1.0 N_M23=1.0 N_M45=1.0 N_M6=1.0 I_PHOTO=0.0
CF (IIN VY) capacitor c=C_FB
CNCG (VY VOUT) capacitor c=C_NCG
CPD (IIN GND) capacitor c=50f
IBIAS1 (TAIL GND) isource type=dc dc=I_BIAS1
IBIAS2 (PBIAS GND) isource type=dc dc=I_BIAS2
IPHOTO (GND IIN) isource type=dc dc=I_PHOTO
M1 (VY IIN GND GND) nmos1 w=(W_M1/max(1, W_M1/1e-05)) l=L_M1 m=N_M1*max(1, W_M1/1e-05) as=(6.000000000000001e-07*((W_M1/max(1, W_M1/1e-05)))) ad=(6.000000000000001e-07*((W_M1/max(1, W_M1/1e-05)))) ps=max(2*((W_M1/max(1, W_M1/1e-05)))+(1.200000000000002e-06),0) pd=max(2*((W_M1/max(1, W_M1/1e-05)))+(1.200000000000002e-06),0)
M2 (VY PBIAS VDD VDD) pmos1 w=(W_M23/max(1, W_M23/1e-05)) l=L_M23 m=N_M23*max(1, W_M23/1e-05) as=(6.000000000000001e-07*((W_M23/max(1, W_M23/1e-05)))) ad=(6.000000000000001e-07*((W_M23/max(1, W_M23/1e-05)))) ps=max(2*((W_M23/max(1, W_M23/1e-05)))+(1.2000000000000004e-06),0) pd=max(2*((W_M23/max(1, W_M23/1e-05)))+(1.2000000000000004e-06),0)
M3 (PBIAS PBIAS VDD VDD) pmos1 w=(W_M23/max(1, W_M23/1e-05)) l=L_M23 m=N_M23*max(1, W_M23/1e-05) as=(6.000000000000001e-07*((W_M23/max(1, W_M23/1e-05)))) ad=(6.000000000000001e-07*((W_M23/max(1, W_M23/1e-05)))) ps=max(2*((W_M23/max(1, W_M23/1e-05)))+(1.2000000000000004e-06),0) pd=max(2*((W_M23/max(1, W_M23/1e-05)))+(1.2000000000000004e-06),0)
M4 (VDD VY TAIL GND) nmos1 w=(W_M45/max(1, W_M45/1e-05)) l=L_M45 m=N_M45*max(1, W_M45/1e-05) as=(6e-07*((W_M45/max(1, W_M45/1e-05)))) ad=(6e-07*((W_M45/max(1, W_M45/1e-05)))) ps=max(2*((W_M45/max(1, W_M45/1e-05)))+(1.1999999999999987e-06),0) pd=max(2*((W_M45/max(1, W_M45/1e-05)))+(1.1999999999999987e-06),0)
M5 (VOUT VBIAS TAIL GND) nmos1 w=(W_M45/max(1, W_M45/1e-05)) l=L_M45 m=N_M45*max(1, W_M45/1e-05) as=(6e-07*((W_M45/max(1, W_M45/1e-05)))) ad=(6e-07*((W_M45/max(1, W_M45/1e-05)))) ps=max(2*((W_M45/max(1, W_M45/1e-05)))+(1.1999999999999987e-06),0) pd=max(2*((W_M45/max(1, W_M45/1e-05)))+(1.1999999999999987e-06),0)
M6 (VOUT VOUT VDD VDD) pmos1 w=(W_M6/max(1, W_M6/1e-05)) l=L_M6 m=N_M6*max(1, W_M6/1e-05) as=(6e-07*((W_M6/max(1, W_M6/1e-05)))) ad=(6e-07*((W_M6/max(1, W_M6/1e-05)))) ps=max(2*((W_M6/max(1, W_M6/1e-05)))+(1.200000000000002e-06),0) pd=max(2*((W_M6/max(1, W_M6/1e-05)))+(1.200000000000002e-06),0)
RF (VY IIN) resistor r=R_F
VBIAS_SOURCE (VBIAS GND) vsource type=dc dc=V_BIAS
ends tia02_dut
