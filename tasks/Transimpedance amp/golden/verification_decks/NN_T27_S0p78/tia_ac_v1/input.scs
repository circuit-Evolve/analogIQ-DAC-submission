// analogiq 0.1.0 testbench - generated, do not edit
// task tia02_task_001  topology tia02_singh_2018
// recipe tia_ac_v1 v1  condition NN_T27_S0p78 (models NN, 27 C, supply 1.40004 V)
// request tia02_restored_public_20261112  candidate eeabff1038ef4ccd
// execution profile search_full
simulator lang=spectre
global 0
include "<CADENCE_SHARED>/FOUNDRY/analog/180nm/models/spectre/gpdk.scs" section=NN
include "dut.scs"

parameters vsup=1.4000400000000002 vneg=0.0
// Supplies (charged to the DUT power metrics).
VSUP (vdd 0) vsource dc=vsup
VNEG (vss 0) vsource dc=vneg

// Photodetector model: ideal current source (AC 1 A) and its capacitance.
IIN (0 iin) isource dc=-2e-05 mag=1
CIN (iin 0) capacitor c=0.0
CL (out 0) capacitor c=1e-14

XDUT (vdd vss iin out) tia02_dut C_FB=1.6704328827205776e-13 C_NCG=1.8654253068635632e-12 I_BIAS1=1.2452370327579653e-05 I_BIAS2=0.00036323944511449757 L_M1=1.8000000000000013e-07 L_M23=1.9069871673236854e-07 L_M45=1.01327771772505e-06 L_M6=3.2755420534706423e-07 N_M1=1.0 N_M23=1.0 N_M45=1.0 N_M6=1.0 R_F=10.000000000000002 V_BIAS=1.2102881986767737 W_M1=3.657458195642558e-06 W_M23=1.4016309970338957e-06 W_M45=4e-07 W_M6=4e-07
op_info info what=oppoint where=rawfile

opts options temp=27.0 tnom=27 reltol=0.0001 save=selected
save VNEG:p VSUP:p iin out vdd vss

ac1 ac start=1000000.0 stop=100000000000.0 dec=50
simulator lang=spice
.include 'measures.sp'
.end
