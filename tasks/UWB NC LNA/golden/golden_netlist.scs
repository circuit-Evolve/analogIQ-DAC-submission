// Golden sizing netlist (curator 2026-10-28): the benchmark DUT subckt with its parameter defaults set to
// the golden design (golden_design.json), taken from the verified run's job NN_T27_S1p00/lna_ip3_v1.
// The DUT subckt and its parameter values are the same in every job of that run (only the testbench changes).
// Instance line of that run: XDUT (rfin rfout b_VB1 b_VB2 vdd) nclna01_dut C_FB=1.4333963407592512e-14 C_GB1=7.880491483319733e-14 C_GB2=2.0613311137757753e-12 C_IN=1.9922987566116098e-12 C_OUT=2.546127454435552e-12 L_IN_SH=7.746...
// Testbench-level variables (bias sources, operating levels) are in golden_design.json and testbench decks.
// Generated by analogiq from dut_benchmark.scs (sha256 c5091f4da969b7a5).
// Connectivity and device models are unchanged except for the listed transformations:
//   - symbols used but not declared in the netlist made DUT parameters: C_FB, C_GB1, C_GB2
//   - M1: junction geometry as/ad/ps/pd rewritten in terms of the bound width (area = Lj*W, perimeter = 2*W + c; Lj and c from the netlist)
//   - M2: junction geometry as/ad/ps/pd rewritten in terms of the bound width (area = Lj*W, perimeter = 2*W + c; Lj and c from the netlist)
//   - M3: junction geometry as/ad/ps/pd rewritten in terms of the bound width (area = Lj*W, perimeter = 2*W + c; Lj and c from the netlist)
//   - M4: junction geometry as/ad/ps/pd rewritten in terms of the bound width (area = Lj*W, perimeter = 2*W + c; Lj and c from the netlist)
//   - netlist parameters bound to sizing variables: C_FB <- C_FB, C_GB1 <- C_GB1, C_GB2 <- C_GB2
//   - widths bound to sizing variables on fold-capable devices are folded symbolically into ceil(W/max) fingers of W/ceil(W/max) (per-device max [1e-05] m): M1, M2, M3, M4
subckt nclna01_dut (VIN VOUT VB1 VB2 VDD)
parameters W_M1=4.482909123499092e-06 L_M1=1.919186687309567e-07 N_M1=3.0 W_M2=4.658532434141864e-06 L_M2=9.390793033481495e-07 N_M2=3.0 W_M3=2.7659602058891925e-05 L_M3=1.8452704108145634e-07 N_M3=7.0 W_M4=2.5386594515528445e-05 L_M4=1.8151429969154623e-07 N_M4=4.0 L_LD1=1.0647775410951928e-10 L_LD2=1.8612834194755287e-08 L_LD3=4.754193388932272e-09 C_GB1=7.880491483319733e-14 C_GB2=2.0613311137757753e-12 C_FB=1.4333963407592512e-14 C_IN=1.9922987566116098e-12 L_IN_SH=7.746635036831963e-09 L_SRC=8.141491842571061e-10 L_IS=1.0050965136965608e-10 L_OUT=3.4546124664767727e-10 C_OUT=2.546127454435552e-12 R_FB=3653.1176337540587 R_B1=414.0291283455854 R_B2=28002.462474215343 R_L1=767.91999691407 R_L2=23.338867641473545
C1 (net16 net6) mimcap area=(((sqrt(1.6e-19+4e-3*C_GB1)-4e-10)/2e-3)*((sqrt(1.6e-19+4e-3*C_GB1)-4e-10)/2e-3)) perim=(4*((sqrt(1.6e-19+4e-3*C_GB1)-4e-10)/2e-3))
C2 (net13 net28) mimcap area=(((sqrt(1.6e-19+4e-3*C_GB2)-4e-10)/2e-3)*((sqrt(1.6e-19+4e-3*C_GB2)-4e-10)/2e-3)) perim=(4*((sqrt(1.6e-19+4e-3*C_GB2)-4e-10)/2e-3))
C3 (net21 net20) mimcap area=(((sqrt(1.6e-19+4e-3*C_FB)-4e-10)/2e-3)*((sqrt(1.6e-19+4e-3*C_FB)-4e-10)/2e-3)) perim=(4*((sqrt(1.6e-19+4e-3*C_FB)-4e-10)/2e-3))
C4 (VOUT net23) capacitor c=C_OUT
CIN (net4 VIN) capacitor c=C_IN
L0 (net28 net4) inductor l=L_SRC
L1 (net43 VDD) inductor l=L_LD1
L2 (net34 VDD) inductor l=L_LD2
L3 (net21 VDD) inductor l=L_LD3
L4 (net19 net16) inductor l=L_IS
L5 (net23 net21) inductor l=L_OUT
LIN (0 net4) inductor l=L_IN_SH
M1 (net29 net6 net28 0) nmos1 w=(W_M1/max(1, W_M1/1e-05)) l=L_M1 m=N_M1*max(1, W_M1/1e-05) as=(6.000000000000001e-07*((W_M1/max(1, W_M1/1e-05)))) ad=(6.000000000000001e-07*((W_M1/max(1, W_M1/1e-05)))) ps=max(2*((W_M1/max(1, W_M1/1e-05)))+(1.200000000000002e-06),0) pd=max(2*((W_M1/max(1, W_M1/1e-05)))+(1.200000000000002e-06),0)
M2 (net16 net29 0 0) nmos1 w=(W_M2/max(1, W_M2/1e-05)) l=L_M2 m=N_M2*max(1, W_M2/1e-05) as=(6.000000000000001e-07*((W_M2/max(1, W_M2/1e-05)))) ad=(6.000000000000001e-07*((W_M2/max(1, W_M2/1e-05)))) ps=max(2*((W_M2/max(1, W_M2/1e-05)))+(1.200000000000002e-06),0) pd=max(2*((W_M2/max(1, W_M2/1e-05)))+(1.200000000000002e-06),0)
M3 (net21 net19 0 0) nmos1 w=(W_M3/max(1, W_M3/1e-05)) l=L_M3 m=N_M3*max(1, W_M3/1e-05) as=(4.5000000000000003e-07*((W_M3/max(1, W_M3/1e-05)))) ad=(3.0000000000000004e-07*((W_M3/max(1, W_M3/1e-05)))) ps=max(2*((W_M3/max(1, W_M3/1e-05)))+(-1.6999999999999993e-05),0) pd=max(2*((W_M3/max(1, W_M3/1e-05)))+(-3.5199999999999995e-05),0)
M4 (net16 net13 0 0) nmos1 w=(W_M4/max(1, W_M4/1e-05)) l=L_M4 m=N_M4*max(1, W_M4/1e-05) as=(4.5e-07*((W_M4/max(1, W_M4/1e-05)))) ad=(3.0000000000000004e-07*((W_M4/max(1, W_M4/1e-05)))) ps=max(2*((W_M4/max(1, W_M4/1e-05)))+(-1.710000000000001e-05),0) pd=max(2*((W_M4/max(1, W_M4/1e-05)))+(-3.54e-05),0)
R1 (net20 net19) resistor r=R_FB
RB1 (net6 VB1) resistor r=R_B1
RB2 (VB2 net13) resistor r=R_B2
RL1 (net29 net43) resistor r=R_L1
RL2 (net16 net34) resistor r=R_L2
ends nclna01_dut
