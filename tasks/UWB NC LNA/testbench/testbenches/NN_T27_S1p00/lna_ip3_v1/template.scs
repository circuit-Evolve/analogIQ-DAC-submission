// analogiq 0.1.0 testbench - generated, do not edit
// task nclna01_task_001  topology nclna01_alinejad_2024
// recipe lna_ip3_v1 v1  condition NN_T27_S1p00 (models NN, 27 C, supply 0.8 V)
// request nclna01_task_001__plan  candidate b824f0fbb2974338
// execution profile search_full
simulator lang=spectre
global 0
include "<CADENCE_SHARED>/FOUNDRY/analog/180nm/models/spectre/gpdk.scs" section=NN
include "dut.scs"

parameters vsup=0.8
// Sizing variables set in the testbench (external-bias values).
parameters V_B1={{V_B1}} V_B2={{V_B2}}
// Supplies (charged to the DUT power metrics).
VSUP (vdd 0) vsource dc=vsup
// External bias (topology external_bias; reported separately as bias power).
VB_VB1 (b_VB1 0) vsource dc=V_B1
VB_VB2 (b_VB2 0) vsource dc=V_B2

// Measurement instrumentation: 50-ohm style ports and ideal DC blocks.
P1 (rfin 0) port r=50.0 num=1 type=sine freq=7400000000.0 dbm=-40.0 fundname="f1" freq2=7480000000.0 dbm2=-40.0 fundname2="f2"
VP2N (rfout p2n) vsource dc=0
P2 (p2n 0) port r=50.0 num=2

XDUT (rfin rfout b_VB1 b_VB2 vdd) nclna01_dut C_FB={{C_FB}} C_GB1={{C_GB1}} C_GB2={{C_GB2}} C_IN={{C_IN}} C_OUT={{C_OUT}} L_IN_SH={{L_IN_SH}} L_IS={{L_IS}} L_LD1={{L_LD1}} L_LD2={{L_LD2}} L_LD3={{L_LD3}} L_M1={{L_M1}} L_M2={{L_M2}} L_M3={{L_M3}} L_M4={{L_M4}} L_OUT={{L_OUT}} L_SRC={{L_SRC}} N_M1={{N_M1}} N_M2={{N_M2}} N_M3={{N_M3}} N_M4={{N_M4}} R_B1={{R_B1}} R_B2={{R_B2}} R_FB={{R_FB}} R_L1={{R_L1}} R_L2={{R_L2}} W_M1={{W_M1}} W_M2={{W_M2}} W_M3={{W_M3}} W_M4={{W_M4}}

opts options temp=27.0 tnom=27 reltol=0.0001 save=selected
save VB_VB1:p VB_VB2:p VSUP:p p2n rfin rfout vdd

hb1 hb funds=["f1" "f2"] maxharms=[3 3] errpreset=moderate
