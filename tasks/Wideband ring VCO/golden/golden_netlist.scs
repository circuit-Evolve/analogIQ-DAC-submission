// Golden sizing netlist (curator 2026-10-28): the benchmark DUT subckt with its parameter defaults set to
// the golden design (golden_design.json), taken from the verified run's job NN_T27_S1p00/osc_pss_tune_v1.
// The DUT subckt and its parameter values are the same in every job of that run (only the testbench changes).
// Instance line of that run: XDUT (vdd b_VSS vctrl outp) gc_0232a331ef36_c27a2916 C_LOAD=1.2940105847534352e-14 C_PUMP=1.6661337689592423e-14 L_DG=2.0082221336350403e-07 L_M11=1.1148739563015059e-07 L_M22=1.0710781560476441e-07 L...
// Testbench-level variables (bias sources, operating levels) are in golden_design.json and testbench decks.
// Generated by analogiq from final.scs (sha256 c53c9bb554002493).
// Connectivity and device models are unchanged except for the listed transformations:
//   - M10: junction geometry as/ad/ps/pd rewritten in terms of the bound width (area = Lj*W, perimeter = 2*W + c; Lj and c from the netlist)
//   - M5: junction geometry as/ad/ps/pd rewritten in terms of the bound width (area = Lj*W, perimeter = 2*W + c; Lj and c from the netlist)
//   - M9: junction geometry as/ad/ps/pd rewritten in terms of the bound width (area = Lj*W, perimeter = 2*W + c; Lj and c from the netlist)
//   - M4: junction geometry as/ad/ps/pd rewritten in terms of the bound width (area = Lj*W, perimeter = 2*W + c; Lj and c from the netlist)
//   - M8: junction geometry as/ad/ps/pd rewritten in terms of the bound width (area = Lj*W, perimeter = 2*W + c; Lj and c from the netlist)
//   - M3: junction geometry as/ad/ps/pd rewritten in terms of the bound width (area = Lj*W, perimeter = 2*W + c; Lj and c from the netlist)
//   - M7: junction geometry as/ad/ps/pd rewritten in terms of the bound width (area = Lj*W, perimeter = 2*W + c; Lj and c from the netlist)
//   - M2: junction geometry as/ad/ps/pd rewritten in terms of the bound width (area = Lj*W, perimeter = 2*W + c; Lj and c from the netlist)
//   - M6: junction geometry as/ad/ps/pd rewritten in terms of the bound width (area = Lj*W, perimeter = 2*W + c; Lj and c from the netlist)
//   - M1: junction geometry as/ad/ps/pd rewritten in terms of the bound width (area = Lj*W, perimeter = 2*W + c; Lj and c from the netlist)
//   - M11: junction geometry as/ad/ps/pd rewritten in terms of the bound width (area = Lj*W, perimeter = 2*W + c; Lj and c from the netlist)
//   - M28: junction geometry as/ad/ps/pd rewritten in terms of the bound width (area = Lj*W, perimeter = 2*W + c; Lj and c from the netlist)
//   - M21: junction geometry as/ad/ps/pd rewritten in terms of the bound width (area = Lj*W, perimeter = 2*W + c; Lj and c from the netlist)
//   - M16: junction geometry as/ad/ps/pd rewritten in terms of the bound width (area = Lj*W, perimeter = 2*W + c; Lj and c from the netlist)
//   - M27: junction geometry as/ad/ps/pd rewritten in terms of the bound width (area = Lj*W, perimeter = 2*W + c; Lj and c from the netlist)
//   - M20: junction geometry as/ad/ps/pd rewritten in terms of the bound width (area = Lj*W, perimeter = 2*W + c; Lj and c from the netlist)
//   - M15: junction geometry as/ad/ps/pd rewritten in terms of the bound width (area = Lj*W, perimeter = 2*W + c; Lj and c from the netlist)
//   - M26: junction geometry as/ad/ps/pd rewritten in terms of the bound width (area = Lj*W, perimeter = 2*W + c; Lj and c from the netlist)
//   - M19: junction geometry as/ad/ps/pd rewritten in terms of the bound width (area = Lj*W, perimeter = 2*W + c; Lj and c from the netlist)
//   - M14: junction geometry as/ad/ps/pd rewritten in terms of the bound width (area = Lj*W, perimeter = 2*W + c; Lj and c from the netlist)
//   - M25: junction geometry as/ad/ps/pd rewritten in terms of the bound width (area = Lj*W, perimeter = 2*W + c; Lj and c from the netlist)
//   - M18: junction geometry as/ad/ps/pd rewritten in terms of the bound width (area = Lj*W, perimeter = 2*W + c; Lj and c from the netlist)
//   - M13: junction geometry as/ad/ps/pd rewritten in terms of the bound width (area = Lj*W, perimeter = 2*W + c; Lj and c from the netlist)
//   - M24: junction geometry as/ad/ps/pd rewritten in terms of the bound width (area = Lj*W, perimeter = 2*W + c; Lj and c from the netlist)
//   - M17: junction geometry as/ad/ps/pd rewritten in terms of the bound width (area = Lj*W, perimeter = 2*W + c; Lj and c from the netlist)
//   - M12: junction geometry as/ad/ps/pd rewritten in terms of the bound width (area = Lj*W, perimeter = 2*W + c; Lj and c from the netlist)
//   - M23: junction geometry as/ad/ps/pd rewritten in terms of the bound width (area = Lj*W, perimeter = 2*W + c; Lj and c from the netlist)
//   - M22: junction geometry as/ad/ps/pd rewritten in terms of the bound width (area = Lj*W, perimeter = 2*W + c; Lj and c from the netlist)
subckt gc_0232a331ef36_c27a2916 (VDD VSS VCON VOSC)
parameters N_M11=2.0 W_M11=1.9022631417413167e-06 L_M11=1.1148739563015059e-07 N_PS=2.0 W_PS=1.7732458487842323e-06 L_PS=1.5482369080215923e-07 N_PCP=9.0 W_PCP=2.111193845307927e-06 L_PCP=4.208264806249547e-07 N_PI=6.0 W_PI=1.1685282345159282e-06 L_PI=1.2611832663850679e-07 N_NI=6.0 W_NI=1.8459991912298766e-06 L_NI=1.311472009042472e-07 N_NS=3.0 W_NS=6.353577592142421e-07 L_NS=6.825605994612687e-07 N_NCP=22.0 W_NCP=8.946638631022571e-07 L_NCP=2.2789387780598196e-07 N_M22=5.0 W_M22=1.1589685884903334e-06 L_M22=1.0710781560476441e-07 N_DG=8.0 W_DG=8.091124514959516e-06 L_DG=2.0082221336350403e-07 N_M23=15.0 W_M23=1.514834198386515e-07 L_M23=1.7728094526847754e-07 C_LOAD=1.2940105847534352e-14 C_PUMP=1.6661337689592423e-14
M10 (VOSC N4 P5 VDD) gpdk090_pmos1v w=W_PI l=L_PI m=N_PI as=(2.8e-07*(W_PI)) ad=(2.8e-07*(W_PI)) ps=max(2*(W_PI)+(5.600000000000001e-07),0) pd=max(2*(W_PI)+(5.600000000000001e-07),0)
M5 (P5 PBIAS VDD VDD) gpdk090_pmos1v w=W_PS l=L_PS m=N_PS as=(2.8e-07*(W_PS)) ad=(2.8e-07*(W_PS)) ps=max(2*(W_PS)+(5.599999999999997e-07),0) pd=max(2*(W_PS)+(5.599999999999997e-07),0)
M9 (N4 N3 P4 VDD) gpdk090_pmos1v w=W_PI l=L_PI m=N_PI as=(2.8e-07*(W_PI)) ad=(2.8e-07*(W_PI)) ps=max(2*(W_PI)+(5.600000000000001e-07),0) pd=max(2*(W_PI)+(5.600000000000001e-07),0)
M4 (P4 VSS VDD VDD) gpdk090_pmos1v w=W_PCP l=L_PCP m=N_PCP as=(2.8e-07*(W_PCP)) ad=(2.8e-07*(W_PCP)) ps=max(2*(W_PCP)+(5.599999999999997e-07),0) pd=max(2*(W_PCP)+(5.599999999999997e-07),0)
M8 (N3 N2 P3 VDD) gpdk090_pmos1v w=W_PI l=L_PI m=N_PI as=(2.8e-07*(W_PI)) ad=(2.8e-07*(W_PI)) ps=max(2*(W_PI)+(5.600000000000001e-07),0) pd=max(2*(W_PI)+(5.600000000000001e-07),0)
M3 (P3 PBIAS VDD VDD) gpdk090_pmos1v w=W_PS l=L_PS m=N_PS as=(2.8e-07*(W_PS)) ad=(2.8e-07*(W_PS)) ps=max(2*(W_PS)+(5.599999999999997e-07),0) pd=max(2*(W_PS)+(5.599999999999997e-07),0)
M7 (N2 N1 P2 VDD) gpdk090_pmos1v w=W_PI l=L_PI m=N_PI as=(2.8e-07*(W_PI)) ad=(2.8e-07*(W_PI)) ps=max(2*(W_PI)+(5.600000000000001e-07),0) pd=max(2*(W_PI)+(5.600000000000001e-07),0)
M2 (P2 VSS VDD VDD) gpdk090_pmos1v w=W_PCP l=L_PCP m=N_PCP as=(2.8e-07*(W_PCP)) ad=(2.8e-07*(W_PCP)) ps=max(2*(W_PCP)+(5.599999999999997e-07),0) pd=max(2*(W_PCP)+(5.599999999999997e-07),0)
M6 (N1 VOSC P1 VDD) gpdk090_pmos1v w=W_PI l=L_PI m=N_PI as=(2.8e-07*(W_PI)) ad=(2.8e-07*(W_PI)) ps=max(2*(W_PI)+(5.600000000000001e-07),0) pd=max(2*(W_PI)+(5.600000000000001e-07),0)
M1 (P1 PBIAS VDD VDD) gpdk090_pmos1v w=W_PS l=L_PS m=N_PS as=(2.8e-07*(W_PS)) ad=(2.8e-07*(W_PS)) ps=max(2*(W_PS)+(5.599999999999997e-07),0) pd=max(2*(W_PS)+(5.599999999999997e-07),0)
M11 (PBIAS PBIAS VDD VDD) gpdk090_pmos1v w=W_M11 l=L_M11 m=N_M11 as=(2.8e-07*(W_M11)) ad=(2.8e-07*(W_M11)) ps=max(2*(W_M11)+(5.600000000000001e-07),0) pd=max(2*(W_M11)+(5.600000000000001e-07),0)
M28 (S5 S5 VSS VSS) gpdk090_nmos1v w=W_DG l=L_DG m=N_DG as=(2.8e-07*(W_DG)) ad=(2.8e-07*(W_DG)) ps=max(2*(W_DG)+(5.600000000000014e-07),0) pd=max(2*(W_DG)+(5.600000000000014e-07),0)
M21 (D5 VCON S5 VSS) gpdk090_nmos1v w=W_NS l=L_NS m=N_NS as=(2.8e-07*(W_NS)) ad=(2.8e-07*(W_NS)) ps=max(2*(W_NS)+(5.599999999999999e-07),0) pd=max(2*(W_NS)+(5.599999999999999e-07),0)
M16 (VOSC N4 D5 VSS) gpdk090_nmos1v w=W_NI l=L_NI m=N_NI as=(2.7999999999999997e-07*(W_NI)) ad=(2.7999999999999997e-07*(W_NI)) ps=max(2*(W_NI)+(5.599999999999997e-07),0) pd=max(2*(W_NI)+(5.599999999999997e-07),0)
M27 (S4 S4 VSS VSS) gpdk090_nmos1v w=W_DG l=L_DG m=N_DG as=(2.8e-07*(W_DG)) ad=(2.8e-07*(W_DG)) ps=max(2*(W_DG)+(5.600000000000014e-07),0) pd=max(2*(W_DG)+(5.600000000000014e-07),0)
M20 (D4 VDD S4 VSS) gpdk090_nmos1v w=W_NCP l=L_NCP m=N_NCP as=(2.8e-07*(W_NCP)) ad=(2.8e-07*(W_NCP)) ps=max(2*(W_NCP)+(5.599999999999997e-07),0) pd=max(2*(W_NCP)+(5.599999999999997e-07),0)
M15 (N4 N3 D4 VSS) gpdk090_nmos1v w=W_NI l=L_NI m=N_NI as=(2.7999999999999997e-07*(W_NI)) ad=(2.7999999999999997e-07*(W_NI)) ps=max(2*(W_NI)+(5.599999999999997e-07),0) pd=max(2*(W_NI)+(5.599999999999997e-07),0)
M26 (S3 S3 VSS VSS) gpdk090_nmos1v w=W_DG l=L_DG m=N_DG as=(2.8e-07*(W_DG)) ad=(2.8e-07*(W_DG)) ps=max(2*(W_DG)+(5.600000000000014e-07),0) pd=max(2*(W_DG)+(5.600000000000014e-07),0)
M19 (D3 VCON S3 VSS) gpdk090_nmos1v w=W_NS l=L_NS m=N_NS as=(2.8e-07*(W_NS)) ad=(2.8e-07*(W_NS)) ps=max(2*(W_NS)+(5.599999999999999e-07),0) pd=max(2*(W_NS)+(5.599999999999999e-07),0)
M14 (N3 N2 D3 VSS) gpdk090_nmos1v w=W_NI l=L_NI m=N_NI as=(2.7999999999999997e-07*(W_NI)) ad=(2.7999999999999997e-07*(W_NI)) ps=max(2*(W_NI)+(5.599999999999997e-07),0) pd=max(2*(W_NI)+(5.599999999999997e-07),0)
M25 (S2 S2 VSS VSS) gpdk090_nmos1v w=W_DG l=L_DG m=N_DG as=(2.8e-07*(W_DG)) ad=(2.8e-07*(W_DG)) ps=max(2*(W_DG)+(5.600000000000014e-07),0) pd=max(2*(W_DG)+(5.600000000000014e-07),0)
M18 (D2 VDD S2 VSS) gpdk090_nmos1v w=W_NCP l=L_NCP m=N_NCP as=(2.8e-07*(W_NCP)) ad=(2.8e-07*(W_NCP)) ps=max(2*(W_NCP)+(5.599999999999997e-07),0) pd=max(2*(W_NCP)+(5.599999999999997e-07),0)
M13 (N2 N1 D2 VSS) gpdk090_nmos1v w=W_NI l=L_NI m=N_NI as=(2.7999999999999997e-07*(W_NI)) ad=(2.7999999999999997e-07*(W_NI)) ps=max(2*(W_NI)+(5.599999999999997e-07),0) pd=max(2*(W_NI)+(5.599999999999997e-07),0)
M24 (S1 S1 VSS VSS) gpdk090_nmos1v w=W_DG l=L_DG m=N_DG as=(2.8e-07*(W_DG)) ad=(2.8e-07*(W_DG)) ps=max(2*(W_DG)+(5.600000000000014e-07),0) pd=max(2*(W_DG)+(5.600000000000014e-07),0)
M17 (D1 VCON S1 VSS) gpdk090_nmos1v w=W_NS l=L_NS m=N_NS as=(2.8e-07*(W_NS)) ad=(2.8e-07*(W_NS)) ps=max(2*(W_NS)+(5.599999999999999e-07),0) pd=max(2*(W_NS)+(5.599999999999999e-07),0)
M12 (N1 VOSC D1 VSS) gpdk090_nmos1v w=W_NI l=L_NI m=N_NI as=(2.7999999999999997e-07*(W_NI)) ad=(2.7999999999999997e-07*(W_NI)) ps=max(2*(W_NI)+(5.599999999999997e-07),0) pd=max(2*(W_NI)+(5.599999999999997e-07),0)
M23 (NBIAS NBIAS VSS VSS) gpdk090_nmos1v w=W_M23 l=L_M23 m=N_M23 as=(5.8e-07*(W_M23)) ad=(5.8e-07*(W_M23)) ps=max(2*(W_M23)+(9.199999999999999e-07),0) pd=max(2*(W_M23)+(9.199999999999999e-07),0)
M22 (PBIAS VCON NBIAS VSS) gpdk090_nmos1v w=W_M22 l=L_M22 m=N_M22 as=(2.7999999999999997e-07*(W_M22)) ad=(2.7999999999999997e-07*(W_M22)) ps=max(2*(W_M22)+(5.599999999999997e-07),0) pd=max(2*(W_M22)+(5.599999999999997e-07),0)
C5 (VOSC VSS) capacitor c=C_LOAD
C4 (N4 VCON) capacitor c=C_PUMP
C3 (N3 VSS) capacitor c=C_LOAD
C2 (N2 VCON) capacitor c=C_PUMP
C1 (N1 VSS) capacitor c=C_LOAD
ends gc_0232a331ef36_c27a2916
