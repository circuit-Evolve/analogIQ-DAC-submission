// analogiq 0.1.0 testbench - generated, do not edit
// task rvco_khan2025_task_001  topology rvco_khan2025_gpdk090
// recipe osc_pss_tune_v1 v1  condition NN_T27_S1p00_MC (Monte Carlo mismatch, 20 samples, seed 1; models NN, 27 C, supply 1.2 V)
// request rvco_khan2025_task_001__plan  candidate 58ebc9713506c327
// execution profile search_full
simulator lang=spectre
global 0
include "<PDK_ROOT>/gpdk090_v4.6/models/spectre/gpdk090.scs" section=NN
include "dut.scs"

parameters cl=1e-14 vctrl=0.45 vsup=1.2
// Supplies (charged to the DUT power metrics).
VSUP (vdd 0) vsource dc=vsup
// External bias (topology external_bias; reported separately as bias power).
VB_VSS (b_VSS 0) vsource dc=0.0

VCTRL (vctrl 0) vsource dc=vctrl
CL1 (outp 0) capacitor c=cl
// Start-up kick: current pulse into outp (start-up assistance, see recipe doc).
IKICK (0 outp) isource type=pulse val0=0 val1=0.0001 delay=0 rise=5.0000000000000005e-12 fall=5.0000000000000005e-12 width=5e-11

XDUT (vdd b_VSS vctrl outp) gc_0232a331ef36_c27a2916 C_LOAD={{C_LOAD}} C_PUMP={{C_PUMP}} L_DG={{L_DG}} L_M11={{L_M11}} L_M22={{L_M22}} L_M23={{L_M23}} L_NCP={{L_NCP}} L_NI={{L_NI}} L_NS={{L_NS}} L_PCP={{L_PCP}} L_PI={{L_PI}} L_PS={{L_PS}} N_DG={{N_DG}} N_M11={{N_M11}} N_M22={{N_M22}} N_M23={{N_M23}} N_NCP={{N_NCP}} N_NI={{N_NI}} N_NS={{N_NS}} N_PCP={{N_PCP}} N_PI={{N_PI}} N_PS={{N_PS}} W_DG={{W_DG}} W_M11={{W_M11}} W_M22={{W_M22}} W_M23={{W_M23}} W_NCP={{W_NCP}} W_NI={{W_NI}} W_NS={{W_NS}} W_PCP={{W_PCP}} W_PI={{W_PI}} W_PS={{W_PS}}

opts options temp=27.0 tnom=27 reltol=0.0001 save=selected
save VB_VSS:p VSUP:p outp vctrl vdd

mcsamp montecarlo numruns=20 seed=1 variations=mismatch savefamilyplots=yes donominal=no {
// osc_sweep_begin (replaced by OscPssTune.prepare when the task has an `estimate` setting)
sw sweep param=vctrl values=[0.45 0.5 0.55 0.6 0.65 0.7 0.75 0.8 0.825 0.85 0.9 0.95 1.0 1.05 1.1 1.15 1.2] {
pss1 (outp 0) pss fund=200000000.0 harms=10 tstab=4e-07 errpreset=conservative
pn1 (outp 0) pnoise start=500000.0 stop=2000000.0 dec=10 maxsideband=10 sweeptype=relative relharmnum=1 noisetype=timeaverage
pss2 (outp 0) pss fund=20000000.0 harms=10 tstab=4e-07 errpreset=conservative
pn2 (outp 0) pnoise start=500000.0 stop=2000000.0 dec=10 maxsideband=10 sweeptype=relative relharmnum=1 noisetype=timeaverage
}
// osc_sweep_end
}
